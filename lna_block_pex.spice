* NGSPICE file created from lna_block.ext - technology: gf180mcuD

.subckt Unnamed_aa715e86 w_n1078_n1609# a_n86_n1181# a_n142_n1389# a_n292_n1181# VSUBS
X0 w_n1078_n1609# w_n1078_n1609# w_n1078_n1609# w_n1078_n1609# pfet_03v3 ad=7.3p pd=21.46u as=29.2p ps=85.84u w=10u l=0.28u
X1 a_n292_n1181# a_n142_n1389# a_n86_n1181# w_n1078_n1609# pfet_03v3 ad=7.5p pd=21.5u as=4.3p ps=10.86u w=10u l=0.28u
X2 a_n86_n1181# a_n142_n1389# a_n292_n1181# w_n1078_n1609# pfet_03v3 ad=4.3p pd=10.86u as=7.5p ps=21.5u w=10u l=0.28u
X3 w_n1078_n1609# w_n1078_n1609# w_n1078_n1609# w_n1078_n1609# pfet_03v3 ad=7.3p pd=21.46u as=0 ps=0 w=10u l=0.28u
C0 a_n86_n1181# a_n292_n1181# 3.10568f
C1 a_n86_n1181# w_n1078_n1609# 0.53563f
C2 a_n292_n1181# w_n1078_n1609# 1.92553f
C3 a_n86_n1181# a_n142_n1389# 0.29284f
C4 a_n292_n1181# a_n142_n1389# 0.22425f
C5 w_n1078_n1609# a_n142_n1389# 0.70401f
C6 a_n86_n1181# VSUBS 0.02943f
C7 a_n292_n1181# VSUBS 0.33447f
C8 a_n142_n1389# VSUBS 0.10135f
C9 w_n1078_n1609# VSUBS 22.767f
.ends

.subckt Unnamed_3c60cbf2 a_n370_n2390# a_n520_n2180# w_n1806_n3110# a_n314_n2180#
+ VSUBS
X0 w_n1806_n3110# w_n1806_n3110# w_n1806_n3110# w_n1806_n3110# nfet_03v3 ad=14.6p pd=41.46u as=58.4p ps=0.16584m w=20u l=0.28u
X1 w_n1806_n3110# w_n1806_n3110# w_n1806_n3110# w_n1806_n3110# nfet_03v3 ad=14.6p pd=41.46u as=0 ps=0 w=20u l=0.28u
X2 a_n520_n2180# a_n370_n2390# a_n314_n2180# w_n1806_n3110# nfet_03v3 ad=15p pd=41.5u as=8.6p ps=20.86u w=20u l=0.28u
X3 a_n314_n2180# a_n370_n2390# a_n520_n2180# w_n1806_n3110# nfet_03v3 ad=8.6p pd=20.86u as=15p ps=41.5u w=20u l=0.28u
X4 a_n520_n2180# a_n370_n2390# a_n314_n2180# w_n1806_n3110# nfet_03v3 ad=8.6p pd=20.86u as=8.6p ps=20.86u w=20u l=0.28u
X5 a_n314_n2180# a_n370_n2390# a_n520_n2180# w_n1806_n3110# nfet_03v3 ad=8.6p pd=20.86u as=8.6p ps=20.86u w=20u l=0.28u
C0 a_n520_n2180# a_n370_n2390# 0.92695f
C1 a_n520_n2180# w_n1806_n3110# 2.45671f
C2 a_n520_n2180# a_n314_n2180# 11.3334f
C3 a_n370_n2390# w_n1806_n3110# 1.5486f
C4 a_n370_n2390# a_n314_n2180# 0.98475f
C5 a_n314_n2180# w_n1806_n3110# 0.54015f
C6 a_n314_n2180# VSUBS 0.42154f
C7 a_n520_n2180# VSUBS 1.76105f
C8 a_n370_n2390# VSUBS 0.25367f
C9 w_n1806_n3110# VSUBS 7.40085f
.ends

.subckt Unnamed_36f005e6 a_n370_n2390# a_n520_n2180# w_n1806_n3110# a_n314_n2180#
+ VSUBS
X0 w_n1806_n3110# w_n1806_n3110# w_n1806_n3110# w_n1806_n3110# nfet_03v3 ad=14.6p pd=41.46u as=58.4p ps=0.16584m w=20u l=0.28u
X1 w_n1806_n3110# w_n1806_n3110# w_n1806_n3110# w_n1806_n3110# nfet_03v3 ad=14.6p pd=41.46u as=0 ps=0 w=20u l=0.28u
X2 a_n520_n2180# a_n370_n2390# a_n314_n2180# w_n1806_n3110# nfet_03v3 ad=15p pd=41.5u as=8.6p ps=20.86u w=20u l=0.28u
X3 a_n314_n2180# a_n370_n2390# a_n520_n2180# w_n1806_n3110# nfet_03v3 ad=8.6p pd=20.86u as=15p ps=41.5u w=20u l=0.28u
X4 a_n520_n2180# a_n370_n2390# a_n314_n2180# w_n1806_n3110# nfet_03v3 ad=8.6p pd=20.86u as=8.6p ps=20.86u w=20u l=0.28u
X5 a_n314_n2180# a_n370_n2390# a_n520_n2180# w_n1806_n3110# nfet_03v3 ad=8.6p pd=20.86u as=8.6p ps=20.86u w=20u l=0.28u
C0 a_n520_n2180# a_n370_n2390# 0.92695f
C1 a_n520_n2180# w_n1806_n3110# 2.45671f
C2 a_n520_n2180# a_n314_n2180# 11.3334f
C3 a_n370_n2390# w_n1806_n3110# 1.5486f
C4 a_n370_n2390# a_n314_n2180# 0.98475f
C5 a_n314_n2180# w_n1806_n3110# 0.54015f
C6 a_n314_n2180# VSUBS 0.42154f
C7 a_n520_n2180# VSUBS 1.76105f
C8 a_n370_n2390# VSUBS 0.25367f
C9 w_n1806_n3110# VSUBS 7.40085f
.ends

.subckt lna_block_62479d0d w_n1806_3170# VSUBS
XUnnamed_aa715e86_0 w_n1806_3170# w_n1806_3170# w_n1806_3170# w_n1806_3170# VSUBS
+ Unnamed_aa715e86
XUnnamed_3c60cbf2_0 Unnamed_3c60cbf2_0/a_n370_n2390# Unnamed_3c60cbf2_0/a_n520_n2180#
+ w_n1806_3170# w_n1806_3170# VSUBS Unnamed_3c60cbf2
XUnnamed_36f005e6_0 w_n1806_3170# w_n1806_3170# w_n1806_3170# w_n1806_3170# VSUBS
+ Unnamed_36f005e6
C0 Unnamed_3c60cbf2_0/a_n370_n2390# w_n1806_3170# 0.07625f
C1 Unnamed_3c60cbf2_0/a_n520_n2180# w_n1806_3170# 0.98588f
C2 Unnamed_3c60cbf2_0/a_n520_n2180# Unnamed_3c60cbf2_0/a_n370_n2390# -0.00122f
C3 Unnamed_3c60cbf2_0/a_n520_n2180# VSUBS 1.76105f
C4 Unnamed_3c60cbf2_0/a_n370_n2390# VSUBS 0.25367f
C5 w_n1806_3170# VSUBS 43.51971f
.ends

.subckt lna_block
Xlna_block_62479d0d_0 w_n1806_3170# VSUBS lna_block_62479d0d
X0 w_n1806_3170.t15 w_n1806_3170.t14 w_n1806_3170.t15 w_n1806_3170.t6 nfet_03v3 ad=15p pd=41.5u as=8.6p ps=20.86u w=0 l=0
X1 w_n1806_3170.t25 w_n1806_3170.t24 w_n1806_3170.t25 w_n1806_3170.t20 nfet_03v3 ad=14.6p pd=41.46u as=0 ps=0 w=0 l=0
X2 w_n1806_3170.t34 w_n1806_3170.t32 w_n1806_3170.t34 w_n1806_3170.t33 pfet_03v3 ad=7.5p pd=21.5u as=4.3p ps=10.86u w=0 l=0
X3 w_n1806_3170.t23 w_n1806_3170.t22 w_n1806_3170.t23 w_n1806_3170.t17 nfet_03v3 ad=14.6p pd=41.46u as=0 ps=0 w=0 l=0
X4 lna_block_62479d0d_0/Unnamed_3c60cbf2_0/a_n520_n2180.t3 lna_block_62479d0d_0/Unnamed_3c60cbf2_0/a_n370_n2390# w_n1806_3170.t7 w_n1806_3170.t6 nfet_03v3 ad=15p pd=41.5u as=8.6p ps=20.86u w=0 l=0
X5 w_n1806_3170.t13 w_n1806_3170.t12 w_n1806_3170.t13 w_n1806_3170.t4 nfet_03v3 ad=8.6p pd=20.86u as=15p ps=41.5u w=0 l=0
X6 w_n1806_3170.t21 w_n1806_3170.t19 w_n1806_3170.t21 w_n1806_3170.t20 nfet_03v3 ad=14.6p pd=41.46u as=0 ps=0 w=0 l=0
X7 w_n1806_3170.t11 w_n1806_3170.t10 w_n1806_3170.t11 w_n1806_3170.t2 nfet_03v3 ad=8.6p pd=20.86u as=8.6p ps=20.86u w=0 l=0
X8 w_n1806_3170.t5 lna_block_62479d0d_0/Unnamed_3c60cbf2_0/a_n370_n2390# lna_block_62479d0d_0/Unnamed_3c60cbf2_0/a_n520_n2180.t2 w_n1806_3170.t4 nfet_03v3 ad=8.6p pd=20.86u as=15p ps=41.5u w=0 l=0
X9 lna_block_62479d0d_0/Unnamed_3c60cbf2_0/a_n520_n2180.t1 lna_block_62479d0d_0/Unnamed_3c60cbf2_0/a_n370_n2390# w_n1806_3170.t3 w_n1806_3170.t2 nfet_03v3 ad=8.6p pd=20.86u as=8.6p ps=20.86u w=0 l=0
X10 w_n1806_3170.t1 lna_block_62479d0d_0/Unnamed_3c60cbf2_0/a_n370_n2390# lna_block_62479d0d_0/Unnamed_3c60cbf2_0/a_n520_n2180.t0 w_n1806_3170.t0 nfet_03v3 ad=8.6p pd=20.86u as=8.6p ps=20.86u w=0 l=0
X11 w_n1806_3170.t31 w_n1806_3170.t29 w_n1806_3170.t31 w_n1806_3170.t30 pfet_03v3 ad=4.3p pd=10.86u as=7.5p ps=21.5u w=0 l=0
X12 w_n1806_3170.t28 w_n1806_3170.t26 w_n1806_3170.t28 w_n1806_3170.t27 pfet_03v3 ad=7.3p pd=21.46u as=0 ps=0 w=0 l=0
X13 w_n1806_3170.t18 w_n1806_3170.t16 w_n1806_3170.t18 w_n1806_3170.t17 nfet_03v3 ad=14.6p pd=41.46u as=0 ps=0 w=0 l=0
X14 w_n1806_3170.t37 w_n1806_3170.t35 w_n1806_3170.t37 w_n1806_3170.t36 pfet_03v3 ad=7.3p pd=21.46u as=0 ps=0 w=0 l=0
X15 w_n1806_3170.t9 w_n1806_3170.t8 w_n1806_3170.t9 w_n1806_3170.t0 nfet_03v3 ad=8.6p pd=20.86u as=8.6p ps=20.86u w=0 l=0
R0 w_n1806_3170.n320 w_n1806_3170.t14 282.5
R1 w_n1806_3170.n318 w_n1806_3170.t12 282.5
R2 w_n1806_3170.n347 w_n1806_3170.t24 278.678
R3 w_n1806_3170.n438 w_n1806_3170.t22 278.678
R4 w_n1806_3170.n5 w_n1806_3170.t16 278.678
R5 w_n1806_3170.n341 w_n1806_3170.t19 278.678
R6 w_n1806_3170.n319 w_n1806_3170.t8 275.055
R7 w_n1806_3170.n317 w_n1806_3170.t10 275.055
R8 w_n1806_3170.n464 w_n1806_3170.n2 266
R9 w_n1806_3170.n464 w_n1806_3170.n3 266
R10 w_n1806_3170.n409 w_n1806_3170.n344 266
R11 w_n1806_3170.n409 w_n1806_3170.n343 266
R12 w_n1806_3170.n442 w_n1806_3170.n1 266
R13 w_n1806_3170.n435 w_n1806_3170.n1 266
R14 w_n1806_3170.n346 w_n1806_3170.n345 266
R15 w_n1806_3170.n406 w_n1806_3170.n345 266
R16 w_n1806_3170.n466 w_n1806_3170.n465 152.927
R17 w_n1806_3170.n86 w_n1806_3170.n81 152.863
R18 w_n1806_3170.n123 w_n1806_3170.n111 152.863
R19 w_n1806_3170.n67 w_n1806_3170.t32 152.758
R20 w_n1806_3170.n67 w_n1806_3170.t29 152.758
R21 w_n1806_3170.n120 w_n1806_3170.t35 148.321
R22 w_n1806_3170.n82 w_n1806_3170.t26 148.321
R23 w_n1806_3170.n408 w_n1806_3170.n407 65.725
R24 w_n1806_3170.n465 w_n1806_3170.n0 65.725
R25 w_n1806_3170.n88 w_n1806_3170.n81 52.3429
R26 w_n1806_3170.n124 w_n1806_3170.n123 52.3429
R27 w_n1806_3170.n140 w_n1806_3170.n75 49.7208
R28 w_n1806_3170.n140 w_n1806_3170.n76 49.7208
R29 w_n1806_3170.n134 w_n1806_3170.n133 49.7208
R30 w_n1806_3170.n132 w_n1806_3170.n104 49.7208
R31 w_n1806_3170.n126 w_n1806_3170.n104 49.7208
R32 w_n1806_3170.n417 w_n1806_3170.n334 41.4018
R33 w_n1806_3170.n417 w_n1806_3170.n337 41.4018
R34 w_n1806_3170.n394 w_n1806_3170.n363 41.4018
R35 w_n1806_3170.n426 w_n1806_3170.n163 41.4018
R36 w_n1806_3170.n448 w_n1806_3170.n9 41.4018
R37 w_n1806_3170.n457 w_n1806_3170.n9 41.4018
R38 w_n1806_3170.t33 w_n1806_3170.n76 39.1553
R39 w_n1806_3170.t30 w_n1806_3170.n132 39.1553
R40 w_n1806_3170.t6 w_n1806_3170.n337 35.7091
R41 w_n1806_3170.n448 w_n1806_3170.t4 35.7091
R42 w_n1806_3170.n388 w_n1806_3170.t0 29.4989
R43 w_n1806_3170.n388 w_n1806_3170.t2 29.4989
R44 w_n1806_3170.n87 w_n1806_3170.t27 25.4822
R45 w_n1806_3170.t36 w_n1806_3170.n125 25.4822
R46 w_n1806_3170.n407 w_n1806_3170.t20 24.3237
R47 w_n1806_3170.t17 w_n1806_3170.n0 24.3237
R48 w_n1806_3170.t27 w_n1806_3170.n75 24.2392
R49 w_n1806_3170.n126 w_n1806_3170.t36 24.2392
R50 w_n1806_3170.t20 w_n1806_3170.n334 17.0785
R51 w_n1806_3170.n457 w_n1806_3170.t17 17.0785
R52 w_n1806_3170.n355 w_n1806_3170.n344 15.5561
R53 w_n1806_3170.n355 w_n1806_3170.n335 15.5561
R54 w_n1806_3170.n361 w_n1806_3170.n335 15.5561
R55 w_n1806_3170.n362 w_n1806_3170.n361 15.5561
R56 w_n1806_3170.n371 w_n1806_3170.n362 15.5561
R57 w_n1806_3170.n374 w_n1806_3170.n371 15.5561
R58 w_n1806_3170.n374 w_n1806_3170.n164 15.5561
R59 w_n1806_3170.n425 w_n1806_3170.n164 15.5561
R60 w_n1806_3170.n425 w_n1806_3170.n151 15.5561
R61 w_n1806_3170.n151 w_n1806_3170.n8 15.5561
R62 w_n1806_3170.n458 w_n1806_3170.n8 15.5561
R63 w_n1806_3170.n458 w_n1806_3170.n3 15.5561
R64 w_n1806_3170.n343 w_n1806_3170.n338 15.5561
R65 w_n1806_3170.n416 w_n1806_3170.n338 15.5561
R66 w_n1806_3170.n416 w_n1806_3170.n339 15.5561
R67 w_n1806_3170.n393 w_n1806_3170.n339 15.5561
R68 w_n1806_3170.n393 w_n1806_3170.n390 15.5561
R69 w_n1806_3170.n390 w_n1806_3170.n389 15.5561
R70 w_n1806_3170.n389 w_n1806_3170.n366 15.5561
R71 w_n1806_3170.n366 w_n1806_3170.n150 15.5561
R72 w_n1806_3170.n449 w_n1806_3170.n150 15.5561
R73 w_n1806_3170.n449 w_n1806_3170.n12 15.5561
R74 w_n1806_3170.n456 w_n1806_3170.n12 15.5561
R75 w_n1806_3170.n456 w_n1806_3170.n2 15.5561
R76 w_n1806_3170.n349 w_n1806_3170.n346 15.5561
R77 w_n1806_3170.n349 w_n1806_3170.n336 15.5561
R78 w_n1806_3170.n396 w_n1806_3170.n336 15.5561
R79 w_n1806_3170.n396 w_n1806_3170.n395 15.5561
R80 w_n1806_3170.n395 w_n1806_3170.n353 15.5561
R81 w_n1806_3170.n380 w_n1806_3170.n353 15.5561
R82 w_n1806_3170.n380 w_n1806_3170.n162 15.5561
R83 w_n1806_3170.n427 w_n1806_3170.n162 15.5561
R84 w_n1806_3170.n427 w_n1806_3170.n152 15.5561
R85 w_n1806_3170.n432 w_n1806_3170.n152 15.5561
R86 w_n1806_3170.n432 w_n1806_3170.n10 15.5561
R87 w_n1806_3170.n435 w_n1806_3170.n10 15.5561
R88 w_n1806_3170.n406 w_n1806_3170.n332 15.5561
R89 w_n1806_3170.n418 w_n1806_3170.n332 15.5561
R90 w_n1806_3170.n418 w_n1806_3170.n333 15.5561
R91 w_n1806_3170.n365 w_n1806_3170.n333 15.5561
R92 w_n1806_3170.n381 w_n1806_3170.n365 15.5561
R93 w_n1806_3170.n387 w_n1806_3170.n381 15.5561
R94 w_n1806_3170.n387 w_n1806_3170.n384 15.5561
R95 w_n1806_3170.n384 w_n1806_3170.n153 15.5561
R96 w_n1806_3170.n447 w_n1806_3170.n153 15.5561
R97 w_n1806_3170.n447 w_n1806_3170.n154 15.5561
R98 w_n1806_3170.n154 w_n1806_3170.n11 15.5561
R99 w_n1806_3170.n442 w_n1806_3170.n11 15.5561
R100 w_n1806_3170.n89 w_n1806_3170.n77 14.0005
R101 w_n1806_3170.n139 w_n1806_3170.n77 14.0005
R102 w_n1806_3170.n139 w_n1806_3170.n78 14.0005
R103 w_n1806_3170.n135 w_n1806_3170.n78 14.0005
R104 w_n1806_3170.n135 w_n1806_3170.n97 14.0005
R105 w_n1806_3170.n131 w_n1806_3170.n97 14.0005
R106 w_n1806_3170.n131 w_n1806_3170.n105 14.0005
R107 w_n1806_3170.n127 w_n1806_3170.n105 14.0005
R108 w_n1806_3170.n127 w_n1806_3170.n111 14.0005
R109 w_n1806_3170.n86 w_n1806_3170.n73 14.0005
R110 w_n1806_3170.n141 w_n1806_3170.n73 14.0005
R111 w_n1806_3170.n141 w_n1806_3170.n74 14.0005
R112 w_n1806_3170.n99 w_n1806_3170.n74 14.0005
R113 w_n1806_3170.n100 w_n1806_3170.n99 14.0005
R114 w_n1806_3170.n103 w_n1806_3170.n100 14.0005
R115 w_n1806_3170.n115 w_n1806_3170.n103 14.0005
R116 w_n1806_3170.n115 w_n1806_3170.n112 14.0005
R117 w_n1806_3170.n113 w_n1806_3170.n112 14.0005
R118 w_n1806_3170.n321 w_n1806_3170.n318 12.5005
R119 w_n1806_3170.n68 w_n1806_3170.n67 12.5005
R120 w_n1806_3170.n321 w_n1806_3170.n320 12.5005
R121 w_n1806_3170.t0 w_n1806_3170.n363 11.9034
R122 w_n1806_3170.t2 w_n1806_3170.n163 11.9034
R123 w_n1806_3170.n134 w_n1806_3170.t33 10.5661
R124 w_n1806_3170.n133 w_n1806_3170.t30 10.5661
R125 w_n1806_3170.n320 w_n1806_3170.n319 9.1985
R126 w_n1806_3170.n318 w_n1806_3170.n317 9.1985
R127 w_n1806_3170.n404 w_n1806_3170.n403 7.18485
R128 w_n1806_3170.n441 w_n1806_3170.n440 7.18485
R129 w_n1806_3170.n463 w_n1806_3170.n4 7.18485
R130 w_n1806_3170.n411 w_n1806_3170.n410 7.18485
R131 w_n1806_3170.n329 w_n1806_3170.n327 6.46666
R132 w_n1806_3170.n319 w_n1806_3170.n316 6.46337
R133 w_n1806_3170.n317 w_n1806_3170.n316 6.46337
R134 w_n1806_3170.n329 w_n1806_3170.n328 6.46333
R135 w_n1806_3170.n90 w_n1806_3170.n89 6.3005
R136 w_n1806_3170.n79 w_n1806_3170.n77 6.3005
R137 w_n1806_3170.n77 w_n1806_3170.n75 6.3005
R138 w_n1806_3170.n139 w_n1806_3170.n138 6.3005
R139 w_n1806_3170.n140 w_n1806_3170.n139 6.3005
R140 w_n1806_3170.n137 w_n1806_3170.n78 6.3005
R141 w_n1806_3170.n78 w_n1806_3170.n76 6.3005
R142 w_n1806_3170.n136 w_n1806_3170.n135 6.3005
R143 w_n1806_3170.n135 w_n1806_3170.n134 6.3005
R144 w_n1806_3170.n97 w_n1806_3170.n96 6.3005
R145 w_n1806_3170.n133 w_n1806_3170.n97 6.3005
R146 w_n1806_3170.n131 w_n1806_3170.n130 6.3005
R147 w_n1806_3170.n132 w_n1806_3170.n131 6.3005
R148 w_n1806_3170.n129 w_n1806_3170.n105 6.3005
R149 w_n1806_3170.n105 w_n1806_3170.n104 6.3005
R150 w_n1806_3170.n128 w_n1806_3170.n127 6.3005
R151 w_n1806_3170.n127 w_n1806_3170.n126 6.3005
R152 w_n1806_3170.n111 w_n1806_3170.n110 6.3005
R153 w_n1806_3170.n125 w_n1806_3170.n111 6.3005
R154 w_n1806_3170.n118 w_n1806_3170.n113 6.3005
R155 w_n1806_3170.n117 w_n1806_3170.n112 6.3005
R156 w_n1806_3170.n126 w_n1806_3170.n112 6.3005
R157 w_n1806_3170.n116 w_n1806_3170.n115 6.3005
R158 w_n1806_3170.n115 w_n1806_3170.n104 6.3005
R159 w_n1806_3170.n103 w_n1806_3170.n102 6.3005
R160 w_n1806_3170.n132 w_n1806_3170.n103 6.3005
R161 w_n1806_3170.n101 w_n1806_3170.n100 6.3005
R162 w_n1806_3170.n133 w_n1806_3170.n100 6.3005
R163 w_n1806_3170.n99 w_n1806_3170.n98 6.3005
R164 w_n1806_3170.n134 w_n1806_3170.n99 6.3005
R165 w_n1806_3170.n74 w_n1806_3170.n71 6.3005
R166 w_n1806_3170.n76 w_n1806_3170.n74 6.3005
R167 w_n1806_3170.n142 w_n1806_3170.n141 6.3005
R168 w_n1806_3170.n141 w_n1806_3170.n140 6.3005
R169 w_n1806_3170.n73 w_n1806_3170.n72 6.3005
R170 w_n1806_3170.n75 w_n1806_3170.n73 6.3005
R171 w_n1806_3170.n86 w_n1806_3170.n85 6.3005
R172 w_n1806_3170.n87 w_n1806_3170.n86 6.3005
R173 w_n1806_3170.n122 w_n1806_3170.n114 6.21641
R174 w_n1806_3170.n91 w_n1806_3170.n80 6.21641
R175 w_n1806_3170.n394 w_n1806_3170.t6 5.69318
R176 w_n1806_3170.n426 w_n1806_3170.t4 5.69318
R177 w_n1806_3170.n443 w_n1806_3170.n442 5.2005
R178 w_n1806_3170.n442 w_n1806_3170.n0 5.2005
R179 w_n1806_3170.n444 w_n1806_3170.n11 5.2005
R180 w_n1806_3170.n457 w_n1806_3170.n11 5.2005
R181 w_n1806_3170.n445 w_n1806_3170.n154 5.2005
R182 w_n1806_3170.n154 w_n1806_3170.n9 5.2005
R183 w_n1806_3170.n447 w_n1806_3170.n446 5.2005
R184 w_n1806_3170.n448 w_n1806_3170.n447 5.2005
R185 w_n1806_3170.n382 w_n1806_3170.n153 5.2005
R186 w_n1806_3170.n426 w_n1806_3170.n153 5.2005
R187 w_n1806_3170.n384 w_n1806_3170.n383 5.2005
R188 w_n1806_3170.n384 w_n1806_3170.n163 5.2005
R189 w_n1806_3170.n387 w_n1806_3170.n386 5.2005
R190 w_n1806_3170.n388 w_n1806_3170.n387 5.2005
R191 w_n1806_3170.n385 w_n1806_3170.n381 5.2005
R192 w_n1806_3170.n381 w_n1806_3170.n363 5.2005
R193 w_n1806_3170.n365 w_n1806_3170.n364 5.2005
R194 w_n1806_3170.n394 w_n1806_3170.n365 5.2005
R195 w_n1806_3170.n333 w_n1806_3170.n326 5.2005
R196 w_n1806_3170.n337 w_n1806_3170.n333 5.2005
R197 w_n1806_3170.n419 w_n1806_3170.n418 5.2005
R198 w_n1806_3170.n418 w_n1806_3170.n417 5.2005
R199 w_n1806_3170.n332 w_n1806_3170.n331 5.2005
R200 w_n1806_3170.n334 w_n1806_3170.n332 5.2005
R201 w_n1806_3170.n406 w_n1806_3170.n405 5.2005
R202 w_n1806_3170.n407 w_n1806_3170.n406 5.2005
R203 w_n1806_3170.n436 w_n1806_3170.n435 5.2005
R204 w_n1806_3170.n435 w_n1806_3170.n0 5.2005
R205 w_n1806_3170.n434 w_n1806_3170.n10 5.2005
R206 w_n1806_3170.n457 w_n1806_3170.n10 5.2005
R207 w_n1806_3170.n433 w_n1806_3170.n432 5.2005
R208 w_n1806_3170.n432 w_n1806_3170.n9 5.2005
R209 w_n1806_3170.n159 w_n1806_3170.n152 5.2005
R210 w_n1806_3170.n448 w_n1806_3170.n152 5.2005
R211 w_n1806_3170.n428 w_n1806_3170.n427 5.2005
R212 w_n1806_3170.n427 w_n1806_3170.n426 5.2005
R213 w_n1806_3170.n162 w_n1806_3170.n161 5.2005
R214 w_n1806_3170.n163 w_n1806_3170.n162 5.2005
R215 w_n1806_3170.n380 w_n1806_3170.n379 5.2005
R216 w_n1806_3170.n388 w_n1806_3170.n380 5.2005
R217 w_n1806_3170.n375 w_n1806_3170.n353 5.2005
R218 w_n1806_3170.n363 w_n1806_3170.n353 5.2005
R219 w_n1806_3170.n395 w_n1806_3170.n352 5.2005
R220 w_n1806_3170.n395 w_n1806_3170.n394 5.2005
R221 w_n1806_3170.n397 w_n1806_3170.n396 5.2005
R222 w_n1806_3170.n396 w_n1806_3170.n337 5.2005
R223 w_n1806_3170.n398 w_n1806_3170.n336 5.2005
R224 w_n1806_3170.n417 w_n1806_3170.n336 5.2005
R225 w_n1806_3170.n399 w_n1806_3170.n349 5.2005
R226 w_n1806_3170.n349 w_n1806_3170.n334 5.2005
R227 w_n1806_3170.n400 w_n1806_3170.n346 5.2005
R228 w_n1806_3170.n407 w_n1806_3170.n346 5.2005
R229 w_n1806_3170.n454 w_n1806_3170.n2 5.2005
R230 w_n1806_3170.n2 w_n1806_3170.n0 5.2005
R231 w_n1806_3170.n456 w_n1806_3170.n455 5.2005
R232 w_n1806_3170.n457 w_n1806_3170.n456 5.2005
R233 w_n1806_3170.n13 w_n1806_3170.n12 5.2005
R234 w_n1806_3170.n12 w_n1806_3170.n9 5.2005
R235 w_n1806_3170.n450 w_n1806_3170.n449 5.2005
R236 w_n1806_3170.n449 w_n1806_3170.n448 5.2005
R237 w_n1806_3170.n150 w_n1806_3170.n149 5.2005
R238 w_n1806_3170.n426 w_n1806_3170.n150 5.2005
R239 w_n1806_3170.n367 w_n1806_3170.n366 5.2005
R240 w_n1806_3170.n366 w_n1806_3170.n163 5.2005
R241 w_n1806_3170.n389 w_n1806_3170.n368 5.2005
R242 w_n1806_3170.n389 w_n1806_3170.n388 5.2005
R243 w_n1806_3170.n391 w_n1806_3170.n390 5.2005
R244 w_n1806_3170.n390 w_n1806_3170.n363 5.2005
R245 w_n1806_3170.n393 w_n1806_3170.n392 5.2005
R246 w_n1806_3170.n394 w_n1806_3170.n393 5.2005
R247 w_n1806_3170.n414 w_n1806_3170.n339 5.2005
R248 w_n1806_3170.n339 w_n1806_3170.n337 5.2005
R249 w_n1806_3170.n416 w_n1806_3170.n415 5.2005
R250 w_n1806_3170.n417 w_n1806_3170.n416 5.2005
R251 w_n1806_3170.n413 w_n1806_3170.n338 5.2005
R252 w_n1806_3170.n338 w_n1806_3170.n334 5.2005
R253 w_n1806_3170.n343 w_n1806_3170.n340 5.2005
R254 w_n1806_3170.n407 w_n1806_3170.n343 5.2005
R255 w_n1806_3170.n460 w_n1806_3170.n3 5.2005
R256 w_n1806_3170.n3 w_n1806_3170.n0 5.2005
R257 w_n1806_3170.n459 w_n1806_3170.n458 5.2005
R258 w_n1806_3170.n458 w_n1806_3170.n457 5.2005
R259 w_n1806_3170.n8 w_n1806_3170.n7 5.2005
R260 w_n1806_3170.n9 w_n1806_3170.n8 5.2005
R261 w_n1806_3170.n423 w_n1806_3170.n151 5.2005
R262 w_n1806_3170.n448 w_n1806_3170.n151 5.2005
R263 w_n1806_3170.n425 w_n1806_3170.n424 5.2005
R264 w_n1806_3170.n426 w_n1806_3170.n425 5.2005
R265 w_n1806_3170.n372 w_n1806_3170.n164 5.2005
R266 w_n1806_3170.n164 w_n1806_3170.n163 5.2005
R267 w_n1806_3170.n374 w_n1806_3170.n373 5.2005
R268 w_n1806_3170.n388 w_n1806_3170.n374 5.2005
R269 w_n1806_3170.n371 w_n1806_3170.n370 5.2005
R270 w_n1806_3170.n371 w_n1806_3170.n363 5.2005
R271 w_n1806_3170.n369 w_n1806_3170.n362 5.2005
R272 w_n1806_3170.n394 w_n1806_3170.n362 5.2005
R273 w_n1806_3170.n361 w_n1806_3170.n360 5.2005
R274 w_n1806_3170.n361 w_n1806_3170.n337 5.2005
R275 w_n1806_3170.n359 w_n1806_3170.n335 5.2005
R276 w_n1806_3170.n417 w_n1806_3170.n335 5.2005
R277 w_n1806_3170.n358 w_n1806_3170.n355 5.2005
R278 w_n1806_3170.n355 w_n1806_3170.n334 5.2005
R279 w_n1806_3170.n354 w_n1806_3170.n344 5.2005
R280 w_n1806_3170.n407 w_n1806_3170.n344 5.2005
R281 w_n1806_3170.n257 w_n1806_3170.n147 5.10898
R282 w_n1806_3170.n247 w_n1806_3170.n147 5.10898
R283 w_n1806_3170.n37 w_n1806_3170.n32 5.10026
R284 w_n1806_3170.n121 w_n1806_3170.n119 4.92413
R285 w_n1806_3170.n84 w_n1806_3170.n83 4.92413
R286 w_n1806_3170.n402 w_n1806_3170.n401 4.91528
R287 w_n1806_3170.n439 w_n1806_3170.n437 4.91528
R288 w_n1806_3170.n462 w_n1806_3170.n461 4.91528
R289 w_n1806_3170.n356 w_n1806_3170.n342 4.91528
R290 w_n1806_3170.n253 w_n1806_3170.n245 4.85463
R291 w_n1806_3170.n253 w_n1806_3170.n252 4.85463
R292 w_n1806_3170.n37 w_n1806_3170.n36 4.8155
R293 w_n1806_3170.n66 w_n1806_3170.n18 4.6445
R294 w_n1806_3170.n315 w_n1806_3170.n314 4.6445
R295 w_n1806_3170.n66 w_n1806_3170.n65 4.6445
R296 w_n1806_3170.n315 w_n1806_3170.n169 4.6445
R297 w_n1806_3170.n315 w_n1806_3170.n171 4.6445
R298 w_n1806_3170.n315 w_n1806_3170.n170 4.6445
R299 w_n1806_3170.n399 w_n1806_3170.n348 4.5005
R300 w_n1806_3170.n398 w_n1806_3170.n350 4.5005
R301 w_n1806_3170.n397 w_n1806_3170.n351 4.5005
R302 w_n1806_3170.n376 w_n1806_3170.n352 4.5005
R303 w_n1806_3170.n377 w_n1806_3170.n375 4.5005
R304 w_n1806_3170.n379 w_n1806_3170.n378 4.5005
R305 w_n1806_3170.n161 w_n1806_3170.n160 4.5005
R306 w_n1806_3170.n429 w_n1806_3170.n428 4.5005
R307 w_n1806_3170.n430 w_n1806_3170.n159 4.5005
R308 w_n1806_3170.n433 w_n1806_3170.n431 4.5005
R309 w_n1806_3170.n434 w_n1806_3170.n158 4.5005
R310 w_n1806_3170.n437 w_n1806_3170.n436 4.5005
R311 w_n1806_3170.n401 w_n1806_3170.n400 4.5005
R312 w_n1806_3170.n91 w_n1806_3170.n90 4.5005
R313 w_n1806_3170.n92 w_n1806_3170.n79 4.5005
R314 w_n1806_3170.n138 w_n1806_3170.n93 4.5005
R315 w_n1806_3170.n137 w_n1806_3170.n94 4.5005
R316 w_n1806_3170.n136 w_n1806_3170.n95 4.5005
R317 w_n1806_3170.n106 w_n1806_3170.n96 4.5005
R318 w_n1806_3170.n130 w_n1806_3170.n107 4.5005
R319 w_n1806_3170.n129 w_n1806_3170.n108 4.5005
R320 w_n1806_3170.n128 w_n1806_3170.n109 4.5005
R321 w_n1806_3170.n114 w_n1806_3170.n110 4.5005
R322 w_n1806_3170.n72 w_n1806_3170.n16 4.5005
R323 w_n1806_3170.n117 w_n1806_3170.n15 4.5005
R324 w_n1806_3170.n119 w_n1806_3170.n118 4.5005
R325 w_n1806_3170.n85 w_n1806_3170.n84 4.5005
R326 w_n1806_3170.n166 w_n1806_3170.n7 4.5005
R327 w_n1806_3170.n459 w_n1806_3170.n6 4.5005
R328 w_n1806_3170.n461 w_n1806_3170.n460 4.5005
R329 w_n1806_3170.n358 w_n1806_3170.n357 4.5005
R330 w_n1806_3170.n359 w_n1806_3170.n167 4.5005
R331 w_n1806_3170.n356 w_n1806_3170.n354 4.5005
R332 w_n1806_3170.n413 w_n1806_3170.n412 4.5005
R333 w_n1806_3170.n415 w_n1806_3170.n14 4.5005
R334 w_n1806_3170.n452 w_n1806_3170.n13 4.5005
R335 w_n1806_3170.n455 w_n1806_3170.n453 4.5005
R336 w_n1806_3170.n454 w_n1806_3170.n4 4.5005
R337 w_n1806_3170.n411 w_n1806_3170.n340 4.5005
R338 w_n1806_3170.n40 w_n1806_3170.n39 4.5005
R339 w_n1806_3170.n30 w_n1806_3170.n29 4.5005
R340 w_n1806_3170.n46 w_n1806_3170.n45 4.5005
R341 w_n1806_3170.n47 w_n1806_3170.n28 4.5005
R342 w_n1806_3170.n50 w_n1806_3170.n49 4.5005
R343 w_n1806_3170.n23 w_n1806_3170.n22 4.5005
R344 w_n1806_3170.n60 w_n1806_3170.n59 4.5005
R345 w_n1806_3170.n61 w_n1806_3170.n20 4.5005
R346 w_n1806_3170.n63 w_n1806_3170.n62 4.5005
R347 w_n1806_3170.n36 w_n1806_3170.n33 4.5005
R348 w_n1806_3170.n40 w_n1806_3170.n35 4.5005
R349 w_n1806_3170.n34 w_n1806_3170.n30 4.5005
R350 w_n1806_3170.n45 w_n1806_3170.n31 4.5005
R351 w_n1806_3170.n28 w_n1806_3170.n27 4.5005
R352 w_n1806_3170.n51 w_n1806_3170.n50 4.5005
R353 w_n1806_3170.n52 w_n1806_3170.n23 4.5005
R354 w_n1806_3170.n59 w_n1806_3170.n25 4.5005
R355 w_n1806_3170.n24 w_n1806_3170.n20 4.5005
R356 w_n1806_3170.n63 w_n1806_3170.n21 4.5005
R357 w_n1806_3170.n64 w_n1806_3170.n18 4.5005
R358 w_n1806_3170.n33 w_n1806_3170.n32 4.5005
R359 w_n1806_3170.n41 w_n1806_3170.n40 4.5005
R360 w_n1806_3170.n42 w_n1806_3170.n30 4.5005
R361 w_n1806_3170.n45 w_n1806_3170.n44 4.5005
R362 w_n1806_3170.n43 w_n1806_3170.n28 4.5005
R363 w_n1806_3170.n50 w_n1806_3170.n26 4.5005
R364 w_n1806_3170.n56 w_n1806_3170.n23 4.5005
R365 w_n1806_3170.n59 w_n1806_3170.n58 4.5005
R366 w_n1806_3170.n57 w_n1806_3170.n20 4.5005
R367 w_n1806_3170.n63 w_n1806_3170.n19 4.5005
R368 w_n1806_3170.n65 w_n1806_3170.n64 4.5005
R369 w_n1806_3170.n451 w_n1806_3170.n450 4.5005
R370 w_n1806_3170.n259 w_n1806_3170.n256 4.5005
R371 w_n1806_3170.n255 w_n1806_3170.n238 4.5005
R372 w_n1806_3170.n263 w_n1806_3170.n244 4.5005
R373 w_n1806_3170.n243 w_n1806_3170.n230 4.5005
R374 w_n1806_3170.n267 w_n1806_3170.n236 4.5005
R375 w_n1806_3170.n235 w_n1806_3170.n223 4.5005
R376 w_n1806_3170.n272 w_n1806_3170.n228 4.5005
R377 w_n1806_3170.n215 w_n1806_3170.n214 4.5005
R378 w_n1806_3170.n277 w_n1806_3170.n276 4.5005
R379 w_n1806_3170.n278 w_n1806_3170.n211 4.5005
R380 w_n1806_3170.n288 w_n1806_3170.n287 4.5005
R381 w_n1806_3170.n279 w_n1806_3170.n202 4.5005
R382 w_n1806_3170.n295 w_n1806_3170.n208 4.5005
R383 w_n1806_3170.n207 w_n1806_3170.n194 4.5005
R384 w_n1806_3170.n299 w_n1806_3170.n200 4.5005
R385 w_n1806_3170.n199 w_n1806_3170.n186 4.5005
R386 w_n1806_3170.n303 w_n1806_3170.n192 4.5005
R387 w_n1806_3170.n191 w_n1806_3170.n178 4.5005
R388 w_n1806_3170.n308 w_n1806_3170.n184 4.5005
R389 w_n1806_3170.n183 w_n1806_3170.n173 4.5005
R390 w_n1806_3170.n312 w_n1806_3170.n176 4.5005
R391 w_n1806_3170.n252 w_n1806_3170.n246 4.5005
R392 w_n1806_3170.n259 w_n1806_3170.n251 4.5005
R393 w_n1806_3170.n250 w_n1806_3170.n238 4.5005
R394 w_n1806_3170.n263 w_n1806_3170.n242 4.5005
R395 w_n1806_3170.n241 w_n1806_3170.n230 4.5005
R396 w_n1806_3170.n267 w_n1806_3170.n234 4.5005
R397 w_n1806_3170.n233 w_n1806_3170.n223 4.5005
R398 w_n1806_3170.n272 w_n1806_3170.n227 4.5005
R399 w_n1806_3170.n226 w_n1806_3170.n215 4.5005
R400 w_n1806_3170.n276 w_n1806_3170.n219 4.5005
R401 w_n1806_3170.n218 w_n1806_3170.n211 4.5005
R402 w_n1806_3170.n288 w_n1806_3170.n213 4.5005
R403 w_n1806_3170.n280 w_n1806_3170.n202 4.5005
R404 w_n1806_3170.n295 w_n1806_3170.n206 4.5005
R405 w_n1806_3170.n205 w_n1806_3170.n194 4.5005
R406 w_n1806_3170.n299 w_n1806_3170.n198 4.5005
R407 w_n1806_3170.n197 w_n1806_3170.n186 4.5005
R408 w_n1806_3170.n303 w_n1806_3170.n190 4.5005
R409 w_n1806_3170.n189 w_n1806_3170.n178 4.5005
R410 w_n1806_3170.n308 w_n1806_3170.n182 4.5005
R411 w_n1806_3170.n181 w_n1806_3170.n173 4.5005
R412 w_n1806_3170.n312 w_n1806_3170.n175 4.5005
R413 w_n1806_3170.n313 w_n1806_3170.n170 4.5005
R414 w_n1806_3170.n246 w_n1806_3170.n245 4.5005
R415 w_n1806_3170.n260 w_n1806_3170.n259 4.5005
R416 w_n1806_3170.n261 w_n1806_3170.n238 4.5005
R417 w_n1806_3170.n263 w_n1806_3170.n262 4.5005
R418 w_n1806_3170.n230 w_n1806_3170.n229 4.5005
R419 w_n1806_3170.n268 w_n1806_3170.n267 4.5005
R420 w_n1806_3170.n269 w_n1806_3170.n223 4.5005
R421 w_n1806_3170.n272 w_n1806_3170.n271 4.5005
R422 w_n1806_3170.n270 w_n1806_3170.n215 4.5005
R423 w_n1806_3170.n276 w_n1806_3170.n221 4.5005
R424 w_n1806_3170.n220 w_n1806_3170.n211 4.5005
R425 w_n1806_3170.n288 w_n1806_3170.n209 4.5005
R426 w_n1806_3170.n293 w_n1806_3170.n202 4.5005
R427 w_n1806_3170.n295 w_n1806_3170.n294 4.5005
R428 w_n1806_3170.n194 w_n1806_3170.n193 4.5005
R429 w_n1806_3170.n300 w_n1806_3170.n299 4.5005
R430 w_n1806_3170.n301 w_n1806_3170.n186 4.5005
R431 w_n1806_3170.n303 w_n1806_3170.n302 4.5005
R432 w_n1806_3170.n178 w_n1806_3170.n177 4.5005
R433 w_n1806_3170.n309 w_n1806_3170.n308 4.5005
R434 w_n1806_3170.n310 w_n1806_3170.n173 4.5005
R435 w_n1806_3170.n312 w_n1806_3170.n311 4.5005
R436 w_n1806_3170.n313 w_n1806_3170.n171 4.5005
R437 w_n1806_3170.n247 w_n1806_3170.n246 4.5005
R438 w_n1806_3170.n259 w_n1806_3170.n249 4.5005
R439 w_n1806_3170.n248 w_n1806_3170.n238 4.5005
R440 w_n1806_3170.n263 w_n1806_3170.n240 4.5005
R441 w_n1806_3170.n239 w_n1806_3170.n230 4.5005
R442 w_n1806_3170.n267 w_n1806_3170.n232 4.5005
R443 w_n1806_3170.n231 w_n1806_3170.n223 4.5005
R444 w_n1806_3170.n272 w_n1806_3170.n225 4.5005
R445 w_n1806_3170.n224 w_n1806_3170.n215 4.5005
R446 w_n1806_3170.n276 w_n1806_3170.n217 4.5005
R447 w_n1806_3170.n216 w_n1806_3170.n211 4.5005
R448 w_n1806_3170.n288 w_n1806_3170.n212 4.5005
R449 w_n1806_3170.n283 w_n1806_3170.n202 4.5005
R450 w_n1806_3170.n295 w_n1806_3170.n204 4.5005
R451 w_n1806_3170.n203 w_n1806_3170.n194 4.5005
R452 w_n1806_3170.n299 w_n1806_3170.n196 4.5005
R453 w_n1806_3170.n195 w_n1806_3170.n186 4.5005
R454 w_n1806_3170.n303 w_n1806_3170.n188 4.5005
R455 w_n1806_3170.n187 w_n1806_3170.n178 4.5005
R456 w_n1806_3170.n308 w_n1806_3170.n180 4.5005
R457 w_n1806_3170.n179 w_n1806_3170.n173 4.5005
R458 w_n1806_3170.n312 w_n1806_3170.n174 4.5005
R459 w_n1806_3170.n313 w_n1806_3170.n169 4.5005
R460 w_n1806_3170.n257 w_n1806_3170.n246 4.5005
R461 w_n1806_3170.n259 w_n1806_3170.n258 4.5005
R462 w_n1806_3170.n238 w_n1806_3170.n237 4.5005
R463 w_n1806_3170.n264 w_n1806_3170.n263 4.5005
R464 w_n1806_3170.n265 w_n1806_3170.n230 4.5005
R465 w_n1806_3170.n267 w_n1806_3170.n266 4.5005
R466 w_n1806_3170.n223 w_n1806_3170.n222 4.5005
R467 w_n1806_3170.n273 w_n1806_3170.n272 4.5005
R468 w_n1806_3170.n274 w_n1806_3170.n215 4.5005
R469 w_n1806_3170.n276 w_n1806_3170.n275 4.5005
R470 w_n1806_3170.n211 w_n1806_3170.n210 4.5005
R471 w_n1806_3170.n289 w_n1806_3170.n288 4.5005
R472 w_n1806_3170.n202 w_n1806_3170.n201 4.5005
R473 w_n1806_3170.n296 w_n1806_3170.n295 4.5005
R474 w_n1806_3170.n297 w_n1806_3170.n194 4.5005
R475 w_n1806_3170.n299 w_n1806_3170.n298 4.5005
R476 w_n1806_3170.n186 w_n1806_3170.n185 4.5005
R477 w_n1806_3170.n304 w_n1806_3170.n303 4.5005
R478 w_n1806_3170.n305 w_n1806_3170.n178 4.5005
R479 w_n1806_3170.n308 w_n1806_3170.n307 4.5005
R480 w_n1806_3170.n306 w_n1806_3170.n173 4.5005
R481 w_n1806_3170.n312 w_n1806_3170.n172 4.5005
R482 w_n1806_3170.n314 w_n1806_3170.n313 4.5005
R483 w_n1806_3170.n423 w_n1806_3170.n422 4.5005
R484 w_n1806_3170.n331 w_n1806_3170.n330 4.5005
R485 w_n1806_3170.n420 w_n1806_3170.n419 4.5005
R486 w_n1806_3170.n421 w_n1806_3170.n326 4.5005
R487 w_n1806_3170.n445 w_n1806_3170.n156 4.5005
R488 w_n1806_3170.n444 w_n1806_3170.n157 4.5005
R489 w_n1806_3170.n443 w_n1806_3170.n441 4.5005
R490 w_n1806_3170.n405 w_n1806_3170.n404 4.5005
R491 w_n1806_3170.n321 w_n1806_3170.n316 4.26081
R492 w_n1806_3170.n89 w_n1806_3170.n88 3.97982
R493 w_n1806_3170.n124 w_n1806_3170.n113 3.97982
R494 w_n1806_3170.n256 w_n1806_3170.n254 2.472
R495 w_n1806_3170.n39 w_n1806_3170.n38 2.46378
R496 w_n1806_3170.n62 w_n1806_3170.n17 2.42688
R497 w_n1806_3170.n176 w_n1806_3170.n168 2.42688
R498 w_n1806_3170.n451 w_n1806_3170.n148 2.21557
R499 w_n1806_3170.n451 w_n1806_3170.n146 2.21557
R500 w_n1806_3170.n451 w_n1806_3170.n145 2.21557
R501 w_n1806_3170.n144 w_n1806_3170.n143 2.21557
R502 w_n1806_3170.n144 w_n1806_3170.n70 2.21557
R503 w_n1806_3170.n144 w_n1806_3170.n69 2.21557
R504 w_n1806_3170.n422 w_n1806_3170.n323 2.21557
R505 w_n1806_3170.n422 w_n1806_3170.n322 2.21557
R506 w_n1806_3170.n422 w_n1806_3170.n165 2.21557
R507 w_n1806_3170.n421 w_n1806_3170.n325 2.21557
R508 w_n1806_3170.n421 w_n1806_3170.n324 2.21557
R509 w_n1806_3170.n421 w_n1806_3170.n155 2.21557
R510 w_n1806_3170.n403 w_n1806_3170.n402 2.18007
R511 w_n1806_3170.n440 w_n1806_3170.n439 2.18007
R512 w_n1806_3170.n463 w_n1806_3170.n462 2.18007
R513 w_n1806_3170.n410 w_n1806_3170.n342 2.18007
R514 w_n1806_3170.n88 w_n1806_3170.n87 2.15819
R515 w_n1806_3170.n125 w_n1806_3170.n124 2.15819
R516 w_n1806_3170.n122 w_n1806_3170.n121 1.20278
R517 w_n1806_3170.n83 w_n1806_3170.n80 1.20278
R518 w_n1806_3170.n347 w_n1806_3170.t25 1.14729
R519 w_n1806_3170.n438 w_n1806_3170.t23 1.14729
R520 w_n1806_3170.n5 w_n1806_3170.t18 1.14729
R521 w_n1806_3170.n341 w_n1806_3170.t21 1.14729
R522 w_n1806_3170.n120 w_n1806_3170.t37 0.794109
R523 w_n1806_3170.n82 w_n1806_3170.t28 0.794109
R524 w_n1806_3170.t31 w_n1806_3170.n53 0.5615
R525 w_n1806_3170.n48 w_n1806_3170.t34 0.5615
R526 w_n1806_3170.n54 w_n1806_3170.t34 0.3015
R527 w_n1806_3170.n54 w_n1806_3170.t31 0.3015
R528 w_n1806_3170.n292 w_n1806_3170.t13 0.289609
R529 w_n1806_3170.n286 w_n1806_3170.t15 0.289609
R530 w_n1806_3170.n402 w_n1806_3170.n347 0.283087
R531 w_n1806_3170.n439 w_n1806_3170.n438 0.283087
R532 w_n1806_3170.n462 w_n1806_3170.n5 0.283087
R533 w_n1806_3170.n342 w_n1806_3170.n341 0.283087
R534 w_n1806_3170.n121 w_n1806_3170.n120 0.282011
R535 w_n1806_3170.n83 w_n1806_3170.n82 0.282011
R536 w_n1806_3170.n55 w_n1806_3170.n54 0.2605
R537 w_n1806_3170.n81 w_n1806_3170.n80 0.217741
R538 w_n1806_3170.n123 w_n1806_3170.n122 0.217741
R539 w_n1806_3170.n291 w_n1806_3170.n290 0.154159
R540 w_n1806_3170.n285 w_n1806_3170.n284 0.154159
R541 w_n1806_3170.n282 w_n1806_3170.n281 0.154159
R542 w_n1806_3170.n400 w_n1806_3170.n399 0.1445
R543 w_n1806_3170.n399 w_n1806_3170.n398 0.1445
R544 w_n1806_3170.n398 w_n1806_3170.n397 0.1445
R545 w_n1806_3170.n397 w_n1806_3170.n352 0.1445
R546 w_n1806_3170.n375 w_n1806_3170.n352 0.1445
R547 w_n1806_3170.n379 w_n1806_3170.n375 0.1445
R548 w_n1806_3170.n379 w_n1806_3170.n161 0.1445
R549 w_n1806_3170.n428 w_n1806_3170.n161 0.1445
R550 w_n1806_3170.n428 w_n1806_3170.n159 0.1445
R551 w_n1806_3170.n433 w_n1806_3170.n159 0.1445
R552 w_n1806_3170.n434 w_n1806_3170.n433 0.1445
R553 w_n1806_3170.n436 w_n1806_3170.n434 0.1445
R554 w_n1806_3170.n401 w_n1806_3170.n348 0.1445
R555 w_n1806_3170.n350 w_n1806_3170.n348 0.1445
R556 w_n1806_3170.n351 w_n1806_3170.n350 0.1445
R557 w_n1806_3170.n376 w_n1806_3170.n351 0.1445
R558 w_n1806_3170.n377 w_n1806_3170.n376 0.1445
R559 w_n1806_3170.n378 w_n1806_3170.n377 0.1445
R560 w_n1806_3170.n378 w_n1806_3170.n160 0.1445
R561 w_n1806_3170.n429 w_n1806_3170.n160 0.1445
R562 w_n1806_3170.n430 w_n1806_3170.n429 0.1445
R563 w_n1806_3170.n431 w_n1806_3170.n430 0.1445
R564 w_n1806_3170.n431 w_n1806_3170.n158 0.1445
R565 w_n1806_3170.n437 w_n1806_3170.n158 0.1445
R566 w_n1806_3170.n157 w_n1806_3170.n156 0.1445
R567 w_n1806_3170.n441 w_n1806_3170.n157 0.1445
R568 w_n1806_3170.n90 w_n1806_3170.n79 0.1445
R569 w_n1806_3170.n138 w_n1806_3170.n79 0.1445
R570 w_n1806_3170.n138 w_n1806_3170.n137 0.1445
R571 w_n1806_3170.n137 w_n1806_3170.n136 0.1445
R572 w_n1806_3170.n136 w_n1806_3170.n96 0.1445
R573 w_n1806_3170.n130 w_n1806_3170.n96 0.1445
R574 w_n1806_3170.n130 w_n1806_3170.n129 0.1445
R575 w_n1806_3170.n129 w_n1806_3170.n128 0.1445
R576 w_n1806_3170.n128 w_n1806_3170.n110 0.1445
R577 w_n1806_3170.n119 w_n1806_3170.n15 0.1445
R578 w_n1806_3170.n92 w_n1806_3170.n91 0.1445
R579 w_n1806_3170.n93 w_n1806_3170.n92 0.1445
R580 w_n1806_3170.n94 w_n1806_3170.n93 0.1445
R581 w_n1806_3170.n95 w_n1806_3170.n94 0.1445
R582 w_n1806_3170.n106 w_n1806_3170.n95 0.1445
R583 w_n1806_3170.n107 w_n1806_3170.n106 0.1445
R584 w_n1806_3170.n108 w_n1806_3170.n107 0.1445
R585 w_n1806_3170.n109 w_n1806_3170.n108 0.1445
R586 w_n1806_3170.n114 w_n1806_3170.n109 0.1445
R587 w_n1806_3170.n84 w_n1806_3170.n16 0.1445
R588 w_n1806_3170.n85 w_n1806_3170.n72 0.1445
R589 w_n1806_3170.n142 w_n1806_3170.n72 0.1445
R590 w_n1806_3170.n98 w_n1806_3170.n71 0.1445
R591 w_n1806_3170.n102 w_n1806_3170.n101 0.1445
R592 w_n1806_3170.n117 w_n1806_3170.n116 0.1445
R593 w_n1806_3170.n118 w_n1806_3170.n117 0.1445
R594 w_n1806_3170.n453 w_n1806_3170.n452 0.1445
R595 w_n1806_3170.n453 w_n1806_3170.n4 0.1445
R596 w_n1806_3170.n166 w_n1806_3170.n6 0.1445
R597 w_n1806_3170.n461 w_n1806_3170.n6 0.1445
R598 w_n1806_3170.n358 w_n1806_3170.n354 0.1445
R599 w_n1806_3170.n359 w_n1806_3170.n358 0.1445
R600 w_n1806_3170.n360 w_n1806_3170.n359 0.1445
R601 w_n1806_3170.n370 w_n1806_3170.n369 0.1445
R602 w_n1806_3170.n373 w_n1806_3170.n372 0.1445
R603 w_n1806_3170.n424 w_n1806_3170.n423 0.1445
R604 w_n1806_3170.n423 w_n1806_3170.n7 0.1445
R605 w_n1806_3170.n459 w_n1806_3170.n7 0.1445
R606 w_n1806_3170.n460 w_n1806_3170.n459 0.1445
R607 w_n1806_3170.n357 w_n1806_3170.n356 0.1445
R608 w_n1806_3170.n357 w_n1806_3170.n167 0.1445
R609 w_n1806_3170.n412 w_n1806_3170.n411 0.1445
R610 w_n1806_3170.n412 w_n1806_3170.n14 0.1445
R611 w_n1806_3170.n413 w_n1806_3170.n340 0.1445
R612 w_n1806_3170.n415 w_n1806_3170.n413 0.1445
R613 w_n1806_3170.n415 w_n1806_3170.n414 0.1445
R614 w_n1806_3170.n392 w_n1806_3170.n391 0.1445
R615 w_n1806_3170.n368 w_n1806_3170.n367 0.1445
R616 w_n1806_3170.n450 w_n1806_3170.n149 0.1445
R617 w_n1806_3170.n450 w_n1806_3170.n13 0.1445
R618 w_n1806_3170.n455 w_n1806_3170.n13 0.1445
R619 w_n1806_3170.n455 w_n1806_3170.n454 0.1445
R620 w_n1806_3170.n36 w_n1806_3170.n35 0.1445
R621 w_n1806_3170.n35 w_n1806_3170.n34 0.1445
R622 w_n1806_3170.n34 w_n1806_3170.n31 0.1445
R623 w_n1806_3170.n31 w_n1806_3170.n27 0.1445
R624 w_n1806_3170.n51 w_n1806_3170.n27 0.1445
R625 w_n1806_3170.n52 w_n1806_3170.n25 0.1445
R626 w_n1806_3170.n25 w_n1806_3170.n24 0.1445
R627 w_n1806_3170.n24 w_n1806_3170.n21 0.1445
R628 w_n1806_3170.n21 w_n1806_3170.n18 0.1445
R629 w_n1806_3170.n39 w_n1806_3170.n29 0.1445
R630 w_n1806_3170.n46 w_n1806_3170.n29 0.1445
R631 w_n1806_3170.n47 w_n1806_3170.n46 0.1445
R632 w_n1806_3170.n49 w_n1806_3170.n47 0.1445
R633 w_n1806_3170.n60 w_n1806_3170.n22 0.1445
R634 w_n1806_3170.n61 w_n1806_3170.n60 0.1445
R635 w_n1806_3170.n62 w_n1806_3170.n61 0.1445
R636 w_n1806_3170.n258 w_n1806_3170.n257 0.1445
R637 w_n1806_3170.n258 w_n1806_3170.n237 0.1445
R638 w_n1806_3170.n264 w_n1806_3170.n237 0.1445
R639 w_n1806_3170.n265 w_n1806_3170.n264 0.1445
R640 w_n1806_3170.n266 w_n1806_3170.n265 0.1445
R641 w_n1806_3170.n266 w_n1806_3170.n222 0.1445
R642 w_n1806_3170.n273 w_n1806_3170.n222 0.1445
R643 w_n1806_3170.n274 w_n1806_3170.n273 0.1445
R644 w_n1806_3170.n275 w_n1806_3170.n274 0.1445
R645 w_n1806_3170.n275 w_n1806_3170.n210 0.1445
R646 w_n1806_3170.n289 w_n1806_3170.n210 0.1445
R647 w_n1806_3170.n296 w_n1806_3170.n201 0.1445
R648 w_n1806_3170.n297 w_n1806_3170.n296 0.1445
R649 w_n1806_3170.n298 w_n1806_3170.n297 0.1445
R650 w_n1806_3170.n298 w_n1806_3170.n185 0.1445
R651 w_n1806_3170.n304 w_n1806_3170.n185 0.1445
R652 w_n1806_3170.n305 w_n1806_3170.n304 0.1445
R653 w_n1806_3170.n307 w_n1806_3170.n305 0.1445
R654 w_n1806_3170.n307 w_n1806_3170.n306 0.1445
R655 w_n1806_3170.n306 w_n1806_3170.n172 0.1445
R656 w_n1806_3170.n314 w_n1806_3170.n172 0.1445
R657 w_n1806_3170.n41 w_n1806_3170.n32 0.1445
R658 w_n1806_3170.n42 w_n1806_3170.n41 0.1445
R659 w_n1806_3170.n44 w_n1806_3170.n42 0.1445
R660 w_n1806_3170.n44 w_n1806_3170.n43 0.1445
R661 w_n1806_3170.n43 w_n1806_3170.n26 0.1445
R662 w_n1806_3170.n58 w_n1806_3170.n56 0.1445
R663 w_n1806_3170.n58 w_n1806_3170.n57 0.1445
R664 w_n1806_3170.n57 w_n1806_3170.n19 0.1445
R665 w_n1806_3170.n65 w_n1806_3170.n19 0.1445
R666 w_n1806_3170.n249 w_n1806_3170.n247 0.1445
R667 w_n1806_3170.n249 w_n1806_3170.n248 0.1445
R668 w_n1806_3170.n248 w_n1806_3170.n240 0.1445
R669 w_n1806_3170.n240 w_n1806_3170.n239 0.1445
R670 w_n1806_3170.n239 w_n1806_3170.n232 0.1445
R671 w_n1806_3170.n232 w_n1806_3170.n231 0.1445
R672 w_n1806_3170.n231 w_n1806_3170.n225 0.1445
R673 w_n1806_3170.n225 w_n1806_3170.n224 0.1445
R674 w_n1806_3170.n224 w_n1806_3170.n217 0.1445
R675 w_n1806_3170.n217 w_n1806_3170.n216 0.1445
R676 w_n1806_3170.n216 w_n1806_3170.n212 0.1445
R677 w_n1806_3170.n283 w_n1806_3170.n204 0.1445
R678 w_n1806_3170.n204 w_n1806_3170.n203 0.1445
R679 w_n1806_3170.n203 w_n1806_3170.n196 0.1445
R680 w_n1806_3170.n196 w_n1806_3170.n195 0.1445
R681 w_n1806_3170.n195 w_n1806_3170.n188 0.1445
R682 w_n1806_3170.n188 w_n1806_3170.n187 0.1445
R683 w_n1806_3170.n187 w_n1806_3170.n180 0.1445
R684 w_n1806_3170.n180 w_n1806_3170.n179 0.1445
R685 w_n1806_3170.n179 w_n1806_3170.n174 0.1445
R686 w_n1806_3170.n174 w_n1806_3170.n169 0.1445
R687 w_n1806_3170.n260 w_n1806_3170.n245 0.1445
R688 w_n1806_3170.n261 w_n1806_3170.n260 0.1445
R689 w_n1806_3170.n262 w_n1806_3170.n261 0.1445
R690 w_n1806_3170.n262 w_n1806_3170.n229 0.1445
R691 w_n1806_3170.n268 w_n1806_3170.n229 0.1445
R692 w_n1806_3170.n269 w_n1806_3170.n268 0.1445
R693 w_n1806_3170.n271 w_n1806_3170.n269 0.1445
R694 w_n1806_3170.n271 w_n1806_3170.n270 0.1445
R695 w_n1806_3170.n270 w_n1806_3170.n221 0.1445
R696 w_n1806_3170.n221 w_n1806_3170.n220 0.1445
R697 w_n1806_3170.n220 w_n1806_3170.n209 0.1445
R698 w_n1806_3170.n294 w_n1806_3170.n293 0.1445
R699 w_n1806_3170.n294 w_n1806_3170.n193 0.1445
R700 w_n1806_3170.n300 w_n1806_3170.n193 0.1445
R701 w_n1806_3170.n301 w_n1806_3170.n300 0.1445
R702 w_n1806_3170.n302 w_n1806_3170.n301 0.1445
R703 w_n1806_3170.n302 w_n1806_3170.n177 0.1445
R704 w_n1806_3170.n309 w_n1806_3170.n177 0.1445
R705 w_n1806_3170.n310 w_n1806_3170.n309 0.1445
R706 w_n1806_3170.n311 w_n1806_3170.n310 0.1445
R707 w_n1806_3170.n311 w_n1806_3170.n171 0.1445
R708 w_n1806_3170.n252 w_n1806_3170.n251 0.1445
R709 w_n1806_3170.n251 w_n1806_3170.n250 0.1445
R710 w_n1806_3170.n250 w_n1806_3170.n242 0.1445
R711 w_n1806_3170.n242 w_n1806_3170.n241 0.1445
R712 w_n1806_3170.n241 w_n1806_3170.n234 0.1445
R713 w_n1806_3170.n234 w_n1806_3170.n233 0.1445
R714 w_n1806_3170.n233 w_n1806_3170.n227 0.1445
R715 w_n1806_3170.n227 w_n1806_3170.n226 0.1445
R716 w_n1806_3170.n226 w_n1806_3170.n219 0.1445
R717 w_n1806_3170.n219 w_n1806_3170.n218 0.1445
R718 w_n1806_3170.n218 w_n1806_3170.n213 0.1445
R719 w_n1806_3170.n280 w_n1806_3170.n206 0.1445
R720 w_n1806_3170.n206 w_n1806_3170.n205 0.1445
R721 w_n1806_3170.n205 w_n1806_3170.n198 0.1445
R722 w_n1806_3170.n198 w_n1806_3170.n197 0.1445
R723 w_n1806_3170.n197 w_n1806_3170.n190 0.1445
R724 w_n1806_3170.n190 w_n1806_3170.n189 0.1445
R725 w_n1806_3170.n189 w_n1806_3170.n182 0.1445
R726 w_n1806_3170.n182 w_n1806_3170.n181 0.1445
R727 w_n1806_3170.n181 w_n1806_3170.n175 0.1445
R728 w_n1806_3170.n175 w_n1806_3170.n170 0.1445
R729 w_n1806_3170.n256 w_n1806_3170.n255 0.1445
R730 w_n1806_3170.n255 w_n1806_3170.n244 0.1445
R731 w_n1806_3170.n244 w_n1806_3170.n243 0.1445
R732 w_n1806_3170.n243 w_n1806_3170.n236 0.1445
R733 w_n1806_3170.n236 w_n1806_3170.n235 0.1445
R734 w_n1806_3170.n235 w_n1806_3170.n228 0.1445
R735 w_n1806_3170.n228 w_n1806_3170.n214 0.1445
R736 w_n1806_3170.n277 w_n1806_3170.n214 0.1445
R737 w_n1806_3170.n278 w_n1806_3170.n277 0.1445
R738 w_n1806_3170.n287 w_n1806_3170.n278 0.1445
R739 w_n1806_3170.n279 w_n1806_3170.n208 0.1445
R740 w_n1806_3170.n208 w_n1806_3170.n207 0.1445
R741 w_n1806_3170.n207 w_n1806_3170.n200 0.1445
R742 w_n1806_3170.n200 w_n1806_3170.n199 0.1445
R743 w_n1806_3170.n199 w_n1806_3170.n192 0.1445
R744 w_n1806_3170.n192 w_n1806_3170.n191 0.1445
R745 w_n1806_3170.n191 w_n1806_3170.n184 0.1445
R746 w_n1806_3170.n184 w_n1806_3170.n183 0.1445
R747 w_n1806_3170.n183 w_n1806_3170.n176 0.1445
R748 w_n1806_3170.n404 w_n1806_3170.n330 0.1445
R749 w_n1806_3170.n420 w_n1806_3170.n330 0.1445
R750 w_n1806_3170.n405 w_n1806_3170.n331 0.1445
R751 w_n1806_3170.n419 w_n1806_3170.n331 0.1445
R752 w_n1806_3170.n419 w_n1806_3170.n326 0.1445
R753 w_n1806_3170.n364 w_n1806_3170.n326 0.1445
R754 w_n1806_3170.n386 w_n1806_3170.n385 0.1445
R755 w_n1806_3170.n383 w_n1806_3170.n382 0.1445
R756 w_n1806_3170.n446 w_n1806_3170.n445 0.1445
R757 w_n1806_3170.n445 w_n1806_3170.n444 0.1445
R758 w_n1806_3170.n444 w_n1806_3170.n443 0.1445
R759 w_n1806_3170.t15 w_n1806_3170.n285 0.13595
R760 w_n1806_3170.n285 w_n1806_3170.t9 0.13595
R761 w_n1806_3170.n291 w_n1806_3170.t11 0.13595
R762 w_n1806_3170.t13 w_n1806_3170.n291 0.13595
R763 w_n1806_3170.t9 w_n1806_3170.n282 0.13595
R764 w_n1806_3170.n282 w_n1806_3170.t11 0.13595
R765 w_n1806_3170.n328 w_n1806_3170.t3 0.13595
R766 w_n1806_3170.n328 w_n1806_3170.t5 0.13595
R767 w_n1806_3170.n327 w_n1806_3170.t7 0.13595
R768 w_n1806_3170.n327 w_n1806_3170.t1 0.13595
R769 w_n1806_3170.n421 w_n1806_3170.n156 0.1211
R770 w_n1806_3170.n452 w_n1806_3170.n451 0.1211
R771 w_n1806_3170.n422 w_n1806_3170.n166 0.1211
R772 w_n1806_3170.n422 w_n1806_3170.n167 0.1211
R773 w_n1806_3170.n451 w_n1806_3170.n14 0.1211
R774 w_n1806_3170.n421 w_n1806_3170.n420 0.1211
R775 w_n1806_3170.n422 w_n1806_3170.n421 0.111132
R776 w_n1806_3170.n403 w_n1806_3170.n345 0.102461
R777 w_n1806_3170.n408 w_n1806_3170.n345 0.102461
R778 w_n1806_3170.n440 w_n1806_3170.n1 0.102461
R779 w_n1806_3170.n465 w_n1806_3170.n1 0.102461
R780 w_n1806_3170.n410 w_n1806_3170.n409 0.102461
R781 w_n1806_3170.n409 w_n1806_3170.n408 0.102461
R782 w_n1806_3170.n464 w_n1806_3170.n463 0.102461
R783 w_n1806_3170.n465 w_n1806_3170.n464 0.102461
R784 w_n1806_3170.n53 w_n1806_3170.n51 0.0725
R785 w_n1806_3170.n53 w_n1806_3170.n52 0.0725
R786 w_n1806_3170.n49 w_n1806_3170.n48 0.0725
R787 w_n1806_3170.n48 w_n1806_3170.n22 0.0725
R788 w_n1806_3170.n290 w_n1806_3170.n289 0.0725
R789 w_n1806_3170.n290 w_n1806_3170.n201 0.0725
R790 w_n1806_3170.n55 w_n1806_3170.n26 0.0725
R791 w_n1806_3170.n56 w_n1806_3170.n55 0.0725
R792 w_n1806_3170.n284 w_n1806_3170.n212 0.0725
R793 w_n1806_3170.n284 w_n1806_3170.n283 0.0725
R794 w_n1806_3170.n292 w_n1806_3170.n209 0.0725
R795 w_n1806_3170.n293 w_n1806_3170.n292 0.0725
R796 w_n1806_3170.n281 w_n1806_3170.n213 0.0725
R797 w_n1806_3170.n281 w_n1806_3170.n280 0.0725
R798 w_n1806_3170.n287 w_n1806_3170.n286 0.0725
R799 w_n1806_3170.n286 w_n1806_3170.n279 0.0725
R800 w_n1806_3170.n143 w_n1806_3170.n142 0.0718661
R801 w_n1806_3170.n98 w_n1806_3170.n70 0.0718661
R802 w_n1806_3170.n102 w_n1806_3170.n69 0.0718661
R803 w_n1806_3170.n369 w_n1806_3170.n323 0.0718661
R804 w_n1806_3170.n373 w_n1806_3170.n322 0.0718661
R805 w_n1806_3170.n424 w_n1806_3170.n165 0.0718661
R806 w_n1806_3170.n414 w_n1806_3170.n148 0.0718661
R807 w_n1806_3170.n368 w_n1806_3170.n146 0.0718661
R808 w_n1806_3170.n149 w_n1806_3170.n145 0.0718661
R809 w_n1806_3170.n392 w_n1806_3170.n148 0.0718661
R810 w_n1806_3170.n391 w_n1806_3170.n146 0.0718661
R811 w_n1806_3170.n367 w_n1806_3170.n145 0.0718661
R812 w_n1806_3170.n143 w_n1806_3170.n71 0.0718661
R813 w_n1806_3170.n101 w_n1806_3170.n70 0.0718661
R814 w_n1806_3170.n116 w_n1806_3170.n69 0.0718661
R815 w_n1806_3170.n360 w_n1806_3170.n323 0.0718661
R816 w_n1806_3170.n370 w_n1806_3170.n322 0.0718661
R817 w_n1806_3170.n372 w_n1806_3170.n165 0.0718661
R818 w_n1806_3170.n385 w_n1806_3170.n325 0.0718661
R819 w_n1806_3170.n383 w_n1806_3170.n324 0.0718661
R820 w_n1806_3170.n446 w_n1806_3170.n155 0.0718661
R821 w_n1806_3170.n364 w_n1806_3170.n325 0.0718661
R822 w_n1806_3170.n386 w_n1806_3170.n324 0.0718661
R823 w_n1806_3170.n382 w_n1806_3170.n155 0.0718661
R824 w_n1806_3170.n451 w_n1806_3170.n144 0.066666
R825 w_n1806_3170.n144 w_n1806_3170.n15 0.0491
R826 w_n1806_3170.n144 w_n1806_3170.n16 0.0491
R827 w_n1806_3170.n321 w_n1806_3170.n315 0.0289585
R828 w_n1806_3170.n68 w_n1806_3170.n66 0.0252233
R829 w_n1806_3170.n451 w_n1806_3170.n147 0.0207767
R830 w_n1806_3170.n421 w_n1806_3170.n329 0.0207767
R831 w_n1806_3170.n254 w_n1806_3170.n253 0.0180156
R832 w_n1806_3170.n254 w_n1806_3170.n246 0.0167742
R833 w_n1806_3170.n144 w_n1806_3170.n68 0.01633
R834 w_n1806_3170.n422 w_n1806_3170.n321 0.01633
R835 w_n1806_3170.n38 w_n1806_3170.n37 0.0161225
R836 w_n1806_3170.n38 w_n1806_3170.n33 0.0151332
R837 w_n1806_3170.n40 w_n1806_3170.n33 0.0147292
R838 w_n1806_3170.n40 w_n1806_3170.n30 0.0147292
R839 w_n1806_3170.n45 w_n1806_3170.n30 0.0147292
R840 w_n1806_3170.n45 w_n1806_3170.n28 0.0147292
R841 w_n1806_3170.n50 w_n1806_3170.n28 0.0147292
R842 w_n1806_3170.n50 w_n1806_3170.n23 0.0147292
R843 w_n1806_3170.n59 w_n1806_3170.n23 0.0147292
R844 w_n1806_3170.n59 w_n1806_3170.n20 0.0147292
R845 w_n1806_3170.n63 w_n1806_3170.n20 0.0147292
R846 w_n1806_3170.n64 w_n1806_3170.n63 0.0147292
R847 w_n1806_3170.n259 w_n1806_3170.n246 0.0147292
R848 w_n1806_3170.n259 w_n1806_3170.n238 0.0147292
R849 w_n1806_3170.n263 w_n1806_3170.n238 0.0147292
R850 w_n1806_3170.n263 w_n1806_3170.n230 0.0147292
R851 w_n1806_3170.n267 w_n1806_3170.n230 0.0147292
R852 w_n1806_3170.n267 w_n1806_3170.n223 0.0147292
R853 w_n1806_3170.n272 w_n1806_3170.n223 0.0147292
R854 w_n1806_3170.n272 w_n1806_3170.n215 0.0147292
R855 w_n1806_3170.n276 w_n1806_3170.n215 0.0147292
R856 w_n1806_3170.n276 w_n1806_3170.n211 0.0147292
R857 w_n1806_3170.n288 w_n1806_3170.n211 0.0147292
R858 w_n1806_3170.n288 w_n1806_3170.n202 0.0147292
R859 w_n1806_3170.n295 w_n1806_3170.n202 0.0147292
R860 w_n1806_3170.n295 w_n1806_3170.n194 0.0147292
R861 w_n1806_3170.n299 w_n1806_3170.n194 0.0147292
R862 w_n1806_3170.n299 w_n1806_3170.n186 0.0147292
R863 w_n1806_3170.n303 w_n1806_3170.n186 0.0147292
R864 w_n1806_3170.n303 w_n1806_3170.n178 0.0147292
R865 w_n1806_3170.n308 w_n1806_3170.n178 0.0147292
R866 w_n1806_3170.n308 w_n1806_3170.n173 0.0147292
R867 w_n1806_3170.n312 w_n1806_3170.n173 0.0147292
R868 w_n1806_3170.n313 w_n1806_3170.n312 0.0147292
R869 w_n1806_3170.n66 w_n1806_3170.n17 0.00821544
R870 w_n1806_3170.n315 w_n1806_3170.n168 0.00821544
R871 w_n1806_3170.n64 w_n1806_3170.n17 0.0079917
R872 w_n1806_3170.n313 w_n1806_3170.n168 0.0079917
R873 lna_block_62479d0d_0/Unnamed_3c60cbf2_0/a_n520_n2180.t2 lna_block_62479d0d_0/Unnamed_3c60cbf2_0/a_n520_n2180.n1 6.55396
R874 lna_block_62479d0d_0/Unnamed_3c60cbf2_0/a_n520_n2180.n1 lna_block_62479d0d_0/Unnamed_3c60cbf2_0/a_n520_n2180.t3 6.55296
R875 lna_block_62479d0d_0/Unnamed_3c60cbf2_0/a_n520_n2180.n1 lna_block_62479d0d_0/Unnamed_3c60cbf2_0/a_n520_n2180.n0 6.21231
R876 lna_block_62479d0d_0/Unnamed_3c60cbf2_0/a_n520_n2180.n0 lna_block_62479d0d_0/Unnamed_3c60cbf2_0/a_n520_n2180.t0 0.13595
R877 lna_block_62479d0d_0/Unnamed_3c60cbf2_0/a_n520_n2180.n0 lna_block_62479d0d_0/Unnamed_3c60cbf2_0/a_n520_n2180.t1 0.13595
C0 lna_block_62479d0d_0/Unnamed_3c60cbf2_0/a_n520_n2180.t3 VSUBS 4.31503f
C1 lna_block_62479d0d_0/Unnamed_3c60cbf2_0/a_n520_n2180.t0 VSUBS 0.56587f
C2 lna_block_62479d0d_0/Unnamed_3c60cbf2_0/a_n520_n2180.t1 VSUBS 0.56587f
C3 lna_block_62479d0d_0/Unnamed_3c60cbf2_0/a_n520_n2180.n0 VSUBS 3.53861f
C4 lna_block_62479d0d_0/Unnamed_3c60cbf2_0/a_n520_n2180.n1 VSUBS 1.49981f
C5 lna_block_62479d0d_0/Unnamed_3c60cbf2_0/a_n520_n2180.t2 VSUBS 4.31481f
C6 w_n1806_3170.n0 VSUBS 0.31342f
C7 w_n1806_3170.n1 VSUBS 0.02832f
C8 w_n1806_3170.n2 VSUBS 0.01529f
C9 w_n1806_3170.n3 VSUBS 0.01529f
C10 w_n1806_3170.n4 VSUBS 0.01133f
C11 w_n1806_3170.t16 VSUBS 0.02429f
C12 w_n1806_3170.t18 VSUBS 0.23134f
C13 w_n1806_3170.n5 VSUBS 0.05257f
C14 w_n1806_3170.n6 VSUBS 0.00229f
C15 w_n1806_3170.n7 VSUBS 0.00229f
C16 w_n1806_3170.n8 VSUBS 0.00165f
C17 w_n1806_3170.n9 VSUBS 0.2882f
C18 w_n1806_3170.n10 VSUBS 0.00165f
C19 w_n1806_3170.t17 VSUBS 0.1441f
C20 w_n1806_3170.n11 VSUBS 0.00165f
C21 w_n1806_3170.n12 VSUBS 0.00165f
C22 w_n1806_3170.n13 VSUBS 0.00229f
C23 w_n1806_3170.n14 VSUBS 0.00211f
C24 w_n1806_3170.n15 VSUBS 0.00153f
C25 w_n1806_3170.n16 VSUBS 0.00153f
C26 w_n1806_3170.n17 VSUBS 0
C27 w_n1806_3170.n18 VSUBS 0.00321f
C28 w_n1806_3170.n19 VSUBS 0.00229f
C29 w_n1806_3170.n20 VSUBS 0.02322f
C30 w_n1806_3170.n21 VSUBS 0.00229f
C31 w_n1806_3170.n22 VSUBS 0.00172f
C32 w_n1806_3170.n23 VSUBS 0.02322f
C33 w_n1806_3170.n24 VSUBS 0.00229f
C34 w_n1806_3170.n25 VSUBS 0.00229f
C35 w_n1806_3170.n26 VSUBS 0.00172f
C36 w_n1806_3170.t34 VSUBS 0.03889f
C37 w_n1806_3170.n27 VSUBS 0.00229f
C38 w_n1806_3170.n28 VSUBS 0.02322f
C39 w_n1806_3170.n29 VSUBS 0.00229f
C40 w_n1806_3170.n30 VSUBS 0.02322f
C41 w_n1806_3170.n31 VSUBS 0.00229f
C42 w_n1806_3170.n32 VSUBS 0.00936f
C43 w_n1806_3170.n33 VSUBS 0.03556f
C44 w_n1806_3170.n34 VSUBS 0.00229f
C45 w_n1806_3170.n35 VSUBS 0.00229f
C46 w_n1806_3170.n36 VSUBS 0.00614f
C47 w_n1806_3170.n37 VSUBS 0.06391f
C48 w_n1806_3170.n38 VSUBS 0
C49 w_n1806_3170.n39 VSUBS 0.00808f
C50 w_n1806_3170.n40 VSUBS 0.02322f
C51 w_n1806_3170.n41 VSUBS 0.00229f
C52 w_n1806_3170.n42 VSUBS 0.00229f
C53 w_n1806_3170.n43 VSUBS 0.00229f
C54 w_n1806_3170.n44 VSUBS 0.00229f
C55 w_n1806_3170.n45 VSUBS 0.02322f
C56 w_n1806_3170.n46 VSUBS 0.00229f
C57 w_n1806_3170.n47 VSUBS 0.00229f
C58 w_n1806_3170.n48 VSUBS 0.01761f
C59 w_n1806_3170.n49 VSUBS 0.00172f
C60 w_n1806_3170.n50 VSUBS 0.02322f
C61 w_n1806_3170.n51 VSUBS 0.00172f
C62 w_n1806_3170.n52 VSUBS 0.00172f
C63 w_n1806_3170.n53 VSUBS 0.01761f
C64 w_n1806_3170.t31 VSUBS 0.03889f
C65 w_n1806_3170.n54 VSUBS 0.02467f
C66 w_n1806_3170.n55 VSUBS 0.00115f
C67 w_n1806_3170.n56 VSUBS 0.00172f
C68 w_n1806_3170.n57 VSUBS 0.00229f
C69 w_n1806_3170.n58 VSUBS 0.00229f
C70 w_n1806_3170.n59 VSUBS 0.02322f
C71 w_n1806_3170.n60 VSUBS 0.00229f
C72 w_n1806_3170.n61 VSUBS 0.00229f
C73 w_n1806_3170.n62 VSUBS 0.00531f
C74 w_n1806_3170.n63 VSUBS 0.02322f
C75 w_n1806_3170.n64 VSUBS 0.02322f
C76 w_n1806_3170.n65 VSUBS 0.00321f
C77 w_n1806_3170.n66 VSUBS 0.03187f
C78 w_n1806_3170.t32 VSUBS 0.0124f
C79 w_n1806_3170.t29 VSUBS 0.0124f
C80 w_n1806_3170.n67 VSUBS 0.01287f
C81 w_n1806_3170.n68 VSUBS 0.03401f
C82 w_n1806_3170.n71 VSUBS 0.00229f
C83 w_n1806_3170.n72 VSUBS 0.00229f
C84 w_n1806_3170.n73 VSUBS 0.00165f
C85 w_n1806_3170.n74 VSUBS 0.00165f
C86 w_n1806_3170.n75 VSUBS 0.05492f
C87 w_n1806_3170.n76 VSUBS 0.06599f
C88 w_n1806_3170.n77 VSUBS 0.00165f
C89 w_n1806_3170.n78 VSUBS 0.00165f
C90 w_n1806_3170.n79 VSUBS 0.00229f
C91 w_n1806_3170.n80 VSUBS 0.02642f
C92 w_n1806_3170.n81 VSUBS 0.12172f
C93 w_n1806_3170.t26 VSUBS 0.01227f
C94 w_n1806_3170.t28 VSUBS 0.09991f
C95 w_n1806_3170.n82 VSUBS 0.04395f
C96 w_n1806_3170.n83 VSUBS 0.01776f
C97 w_n1806_3170.n84 VSUBS 0.00558f
C98 w_n1806_3170.n85 VSUBS 0.00186f
C99 w_n1806_3170.n86 VSUBS 0.01016f
C100 w_n1806_3170.t27 VSUBS 0.03692f
C101 w_n1806_3170.n87 VSUBS 0.08057f
C102 w_n1806_3170.n89 VSUBS 0.01016f
C103 w_n1806_3170.n90 VSUBS 0.00186f
C104 w_n1806_3170.n91 VSUBS 0.0081f
C105 w_n1806_3170.n92 VSUBS 0.00229f
C106 w_n1806_3170.n93 VSUBS 0.00229f
C107 w_n1806_3170.n94 VSUBS 0.00229f
C108 w_n1806_3170.n95 VSUBS 0.00229f
C109 w_n1806_3170.n96 VSUBS 0.00229f
C110 w_n1806_3170.n97 VSUBS 0.00165f
C111 w_n1806_3170.t33 VSUBS 0.03692f
C112 w_n1806_3170.n98 VSUBS 0.00229f
C113 w_n1806_3170.n99 VSUBS 0.00165f
C114 w_n1806_3170.n100 VSUBS 0.00165f
C115 w_n1806_3170.n101 VSUBS 0.00229f
C116 w_n1806_3170.n102 VSUBS 0.00229f
C117 w_n1806_3170.n103 VSUBS 0.00165f
C118 w_n1806_3170.n104 VSUBS 0.07384f
C119 w_n1806_3170.n105 VSUBS 0.00165f
C120 w_n1806_3170.n106 VSUBS 0.00229f
C121 w_n1806_3170.n107 VSUBS 0.00229f
C122 w_n1806_3170.n108 VSUBS 0.00229f
C123 w_n1806_3170.n109 VSUBS 0.00229f
C124 w_n1806_3170.n110 VSUBS 0.00186f
C125 w_n1806_3170.n111 VSUBS 0.01016f
C126 w_n1806_3170.n112 VSUBS 0.00165f
C127 w_n1806_3170.n113 VSUBS 0.01016f
C128 w_n1806_3170.n114 VSUBS 0.0081f
C129 w_n1806_3170.n115 VSUBS 0.00165f
C130 w_n1806_3170.n116 VSUBS 0.00229f
C131 w_n1806_3170.n117 VSUBS 0.00229f
C132 w_n1806_3170.n118 VSUBS 0.00186f
C133 w_n1806_3170.n119 VSUBS 0.00558f
C134 w_n1806_3170.t35 VSUBS 0.01227f
C135 w_n1806_3170.t37 VSUBS 0.09991f
C136 w_n1806_3170.n120 VSUBS 0.04395f
C137 w_n1806_3170.n121 VSUBS 0.01776f
C138 w_n1806_3170.n122 VSUBS 0.02642f
C139 w_n1806_3170.n123 VSUBS 0.12172f
C140 w_n1806_3170.n125 VSUBS 0.08057f
C141 w_n1806_3170.t36 VSUBS 0.03692f
C142 w_n1806_3170.n126 VSUBS 0.05492f
C143 w_n1806_3170.n127 VSUBS 0.00165f
C144 w_n1806_3170.n128 VSUBS 0.00229f
C145 w_n1806_3170.n129 VSUBS 0.00229f
C146 w_n1806_3170.n130 VSUBS 0.00229f
C147 w_n1806_3170.n131 VSUBS 0.00165f
C148 w_n1806_3170.n132 VSUBS 0.06599f
C149 w_n1806_3170.t30 VSUBS 0.03692f
C150 w_n1806_3170.n133 VSUBS 0.04477f
C151 w_n1806_3170.n134 VSUBS 0.04477f
C152 w_n1806_3170.n135 VSUBS 0.00165f
C153 w_n1806_3170.n136 VSUBS 0.00229f
C154 w_n1806_3170.n137 VSUBS 0.00229f
C155 w_n1806_3170.n138 VSUBS 0.00229f
C156 w_n1806_3170.n139 VSUBS 0.00165f
C157 w_n1806_3170.n140 VSUBS 0.07384f
C158 w_n1806_3170.n141 VSUBS 0.00165f
C159 w_n1806_3170.n142 VSUBS 0.00229f
C160 w_n1806_3170.n144 VSUBS 0.06768f
C161 w_n1806_3170.n147 VSUBS 0.03223f
C162 w_n1806_3170.n149 VSUBS 0.00229f
C163 w_n1806_3170.n150 VSUBS 0.00165f
C164 w_n1806_3170.t4 VSUBS 0.1441f
C165 w_n1806_3170.n151 VSUBS 0.00165f
C166 w_n1806_3170.n152 VSUBS 0.00165f
C167 w_n1806_3170.n153 VSUBS 0.00165f
C168 w_n1806_3170.n154 VSUBS 0.00165f
C169 w_n1806_3170.n156 VSUBS 0.00211f
C170 w_n1806_3170.n157 VSUBS 0.00229f
C171 w_n1806_3170.n158 VSUBS 0.00229f
C172 w_n1806_3170.n159 VSUBS 0.00229f
C173 w_n1806_3170.n160 VSUBS 0.00229f
C174 w_n1806_3170.n161 VSUBS 0.00229f
C175 w_n1806_3170.n162 VSUBS 0.00165f
C176 w_n1806_3170.n163 VSUBS 0.18553f
C177 w_n1806_3170.n164 VSUBS 0.00165f
C178 w_n1806_3170.n166 VSUBS 0.00211f
C179 w_n1806_3170.n167 VSUBS 0.00211f
C180 w_n1806_3170.n168 VSUBS 0
C181 w_n1806_3170.n169 VSUBS 0.00269f
C182 w_n1806_3170.n170 VSUBS 0.00269f
C183 w_n1806_3170.n171 VSUBS 0.00269f
C184 w_n1806_3170.n172 VSUBS 0.00229f
C185 w_n1806_3170.n173 VSUBS 0.02322f
C186 w_n1806_3170.n174 VSUBS 0.00229f
C187 w_n1806_3170.n175 VSUBS 0.00229f
C188 w_n1806_3170.n176 VSUBS 0.00483f
C189 w_n1806_3170.n177 VSUBS 0.00229f
C190 w_n1806_3170.n178 VSUBS 0.02322f
C191 w_n1806_3170.n179 VSUBS 0.00229f
C192 w_n1806_3170.n180 VSUBS 0.00229f
C193 w_n1806_3170.n181 VSUBS 0.00229f
C194 w_n1806_3170.n182 VSUBS 0.00229f
C195 w_n1806_3170.n183 VSUBS 0.00229f
C196 w_n1806_3170.n184 VSUBS 0.00229f
C197 w_n1806_3170.n185 VSUBS 0.00229f
C198 w_n1806_3170.n186 VSUBS 0.02322f
C199 w_n1806_3170.n187 VSUBS 0.00229f
C200 w_n1806_3170.n188 VSUBS 0.00229f
C201 w_n1806_3170.n189 VSUBS 0.00229f
C202 w_n1806_3170.n190 VSUBS 0.00229f
C203 w_n1806_3170.n191 VSUBS 0.00229f
C204 w_n1806_3170.n192 VSUBS 0.00229f
C205 w_n1806_3170.n193 VSUBS 0.00229f
C206 w_n1806_3170.n194 VSUBS 0.02322f
C207 w_n1806_3170.n195 VSUBS 0.00229f
C208 w_n1806_3170.n196 VSUBS 0.00229f
C209 w_n1806_3170.n197 VSUBS 0.00229f
C210 w_n1806_3170.n198 VSUBS 0.00229f
C211 w_n1806_3170.n199 VSUBS 0.00229f
C212 w_n1806_3170.n200 VSUBS 0.00229f
C213 w_n1806_3170.n201 VSUBS 0.00172f
C214 w_n1806_3170.n202 VSUBS 0.02322f
C215 w_n1806_3170.n203 VSUBS 0.00229f
C216 w_n1806_3170.n204 VSUBS 0.00229f
C217 w_n1806_3170.n205 VSUBS 0.00229f
C218 w_n1806_3170.n206 VSUBS 0.00229f
C219 w_n1806_3170.n207 VSUBS 0.00229f
C220 w_n1806_3170.n208 VSUBS 0.00229f
C221 w_n1806_3170.n209 VSUBS 0.00172f
C222 w_n1806_3170.t11 VSUBS 0.04933f
C223 w_n1806_3170.n210 VSUBS 0.00229f
C224 w_n1806_3170.n211 VSUBS 0.02322f
C225 w_n1806_3170.n212 VSUBS 0.00172f
C226 w_n1806_3170.n213 VSUBS 0.00172f
C227 w_n1806_3170.n214 VSUBS 0.00229f
C228 w_n1806_3170.n215 VSUBS 0.02322f
C229 w_n1806_3170.n216 VSUBS 0.00229f
C230 w_n1806_3170.n217 VSUBS 0.00229f
C231 w_n1806_3170.n218 VSUBS 0.00229f
C232 w_n1806_3170.n219 VSUBS 0.00229f
C233 w_n1806_3170.n220 VSUBS 0.00229f
C234 w_n1806_3170.n221 VSUBS 0.00229f
C235 w_n1806_3170.n222 VSUBS 0.00229f
C236 w_n1806_3170.n223 VSUBS 0.02322f
C237 w_n1806_3170.n224 VSUBS 0.00229f
C238 w_n1806_3170.n225 VSUBS 0.00229f
C239 w_n1806_3170.n226 VSUBS 0.00229f
C240 w_n1806_3170.n227 VSUBS 0.00229f
C241 w_n1806_3170.n228 VSUBS 0.00229f
C242 w_n1806_3170.n229 VSUBS 0.00229f
C243 w_n1806_3170.n230 VSUBS 0.02322f
C244 w_n1806_3170.n231 VSUBS 0.00229f
C245 w_n1806_3170.n232 VSUBS 0.00229f
C246 w_n1806_3170.n233 VSUBS 0.00229f
C247 w_n1806_3170.n234 VSUBS 0.00229f
C248 w_n1806_3170.n235 VSUBS 0.00229f
C249 w_n1806_3170.n236 VSUBS 0.00229f
C250 w_n1806_3170.n237 VSUBS 0.00229f
C251 w_n1806_3170.n238 VSUBS 0.02322f
C252 w_n1806_3170.n239 VSUBS 0.00229f
C253 w_n1806_3170.n240 VSUBS 0.00229f
C254 w_n1806_3170.n241 VSUBS 0.00229f
C255 w_n1806_3170.n242 VSUBS 0.00229f
C256 w_n1806_3170.n243 VSUBS 0.00229f
C257 w_n1806_3170.n244 VSUBS 0.00229f
C258 w_n1806_3170.n245 VSUBS 0.00663f
C259 w_n1806_3170.n246 VSUBS 0.03846f
C260 w_n1806_3170.n247 VSUBS 0.0097f
C261 w_n1806_3170.n248 VSUBS 0.00229f
C262 w_n1806_3170.n249 VSUBS 0.00229f
C263 w_n1806_3170.n250 VSUBS 0.00229f
C264 w_n1806_3170.n251 VSUBS 0.00229f
C265 w_n1806_3170.n252 VSUBS 0.00663f
C266 w_n1806_3170.n253 VSUBS 0.04207f
C267 w_n1806_3170.n254 VSUBS 0
C268 w_n1806_3170.n255 VSUBS 0.00229f
C269 w_n1806_3170.n256 VSUBS 0.00853f
C270 w_n1806_3170.n257 VSUBS 0.0097f
C271 w_n1806_3170.n258 VSUBS 0.00229f
C272 w_n1806_3170.n259 VSUBS 0.02322f
C273 w_n1806_3170.n260 VSUBS 0.00229f
C274 w_n1806_3170.n261 VSUBS 0.00229f
C275 w_n1806_3170.n262 VSUBS 0.00229f
C276 w_n1806_3170.n263 VSUBS 0.02322f
C277 w_n1806_3170.n264 VSUBS 0.00229f
C278 w_n1806_3170.n265 VSUBS 0.00229f
C279 w_n1806_3170.n266 VSUBS 0.00229f
C280 w_n1806_3170.n267 VSUBS 0.02322f
C281 w_n1806_3170.n268 VSUBS 0.00229f
C282 w_n1806_3170.n269 VSUBS 0.00229f
C283 w_n1806_3170.n270 VSUBS 0.00229f
C284 w_n1806_3170.n271 VSUBS 0.00229f
C285 w_n1806_3170.n272 VSUBS 0.02322f
C286 w_n1806_3170.n273 VSUBS 0.00229f
C287 w_n1806_3170.n274 VSUBS 0.00229f
C288 w_n1806_3170.n275 VSUBS 0.00229f
C289 w_n1806_3170.n276 VSUBS 0.02322f
C290 w_n1806_3170.n277 VSUBS 0.00229f
C291 w_n1806_3170.n278 VSUBS 0.00229f
C292 w_n1806_3170.n279 VSUBS 0.00172f
C293 w_n1806_3170.n280 VSUBS 0.00172f
C294 w_n1806_3170.n281 VSUBS 0.00115f
C295 w_n1806_3170.n282 VSUBS 0.04933f
C296 w_n1806_3170.t9 VSUBS 0.04933f
C297 w_n1806_3170.n283 VSUBS 0.00172f
C298 w_n1806_3170.n284 VSUBS 0.00115f
C299 w_n1806_3170.n285 VSUBS 0.04933f
C300 w_n1806_3170.t15 VSUBS 0.08196f
C301 w_n1806_3170.n286 VSUBS 0.0299f
C302 w_n1806_3170.n287 VSUBS 0.00172f
C303 w_n1806_3170.n288 VSUBS 0.02322f
C304 w_n1806_3170.n289 VSUBS 0.00172f
C305 w_n1806_3170.n290 VSUBS 0.00115f
C306 w_n1806_3170.n291 VSUBS 0.04933f
C307 w_n1806_3170.t13 VSUBS 0.08196f
C308 w_n1806_3170.n292 VSUBS 0.0299f
C309 w_n1806_3170.n293 VSUBS 0.00172f
C310 w_n1806_3170.n294 VSUBS 0.00229f
C311 w_n1806_3170.n295 VSUBS 0.02322f
C312 w_n1806_3170.n296 VSUBS 0.00229f
C313 w_n1806_3170.n297 VSUBS 0.00229f
C314 w_n1806_3170.n298 VSUBS 0.00229f
C315 w_n1806_3170.n299 VSUBS 0.02322f
C316 w_n1806_3170.n300 VSUBS 0.00229f
C317 w_n1806_3170.n301 VSUBS 0.00229f
C318 w_n1806_3170.n302 VSUBS 0.00229f
C319 w_n1806_3170.n303 VSUBS 0.02322f
C320 w_n1806_3170.n304 VSUBS 0.00229f
C321 w_n1806_3170.n305 VSUBS 0.00229f
C322 w_n1806_3170.n306 VSUBS 0.00229f
C323 w_n1806_3170.n307 VSUBS 0.00229f
C324 w_n1806_3170.n308 VSUBS 0.02322f
C325 w_n1806_3170.n309 VSUBS 0.00229f
C326 w_n1806_3170.n310 VSUBS 0.00229f
C327 w_n1806_3170.n311 VSUBS 0.00229f
C328 w_n1806_3170.n312 VSUBS 0.02322f
C329 w_n1806_3170.n313 VSUBS 0.02322f
C330 w_n1806_3170.n314 VSUBS 0.00269f
C331 w_n1806_3170.n315 VSUBS 0.0349f
C332 w_n1806_3170.n316 VSUBS 0.00147f
C333 w_n1806_3170.t10 VSUBS 0.02415f
C334 w_n1806_3170.n317 VSUBS 0.01079f
C335 w_n1806_3170.t12 VSUBS 0.0244f
C336 w_n1806_3170.n318 VSUBS 0.0115f
C337 w_n1806_3170.t14 VSUBS 0.0244f
C338 w_n1806_3170.t8 VSUBS 0.02415f
C339 w_n1806_3170.n319 VSUBS 0.01079f
C340 w_n1806_3170.n320 VSUBS 0.0115f
C341 w_n1806_3170.n321 VSUBS 0.03981f
C342 w_n1806_3170.n326 VSUBS 0.00229f
C343 w_n1806_3170.t7 VSUBS 0.02467f
C344 w_n1806_3170.t1 VSUBS 0.02467f
C345 w_n1806_3170.n327 VSUBS 0.15707f
C346 w_n1806_3170.t3 VSUBS 0.02467f
C347 w_n1806_3170.t5 VSUBS 0.02467f
C348 w_n1806_3170.n328 VSUBS 1.79263f
C349 w_n1806_3170.n329 VSUBS 0.17661f
C350 w_n1806_3170.n330 VSUBS 0.00229f
C351 w_n1806_3170.n331 VSUBS 0.00229f
C352 w_n1806_3170.n332 VSUBS 0.00165f
C353 w_n1806_3170.n333 VSUBS 0.00165f
C354 w_n1806_3170.n334 VSUBS 0.20354f
C355 w_n1806_3170.n335 VSUBS 0.00165f
C356 w_n1806_3170.n336 VSUBS 0.00165f
C357 w_n1806_3170.n337 VSUBS 0.26839f
C358 w_n1806_3170.n338 VSUBS 0.00165f
C359 w_n1806_3170.n339 VSUBS 0.00165f
C360 w_n1806_3170.n340 VSUBS 0.00186f
C361 w_n1806_3170.t19 VSUBS 0.02429f
C362 w_n1806_3170.t21 VSUBS 0.23134f
C363 w_n1806_3170.n341 VSUBS 0.05257f
C364 w_n1806_3170.n342 VSUBS 0.02489f
C365 w_n1806_3170.n343 VSUBS 0.01529f
C366 w_n1806_3170.n344 VSUBS 0.01529f
C367 w_n1806_3170.n345 VSUBS 0.02832f
C368 w_n1806_3170.n346 VSUBS 0.01529f
C369 w_n1806_3170.t20 VSUBS 0.1441f
C370 w_n1806_3170.t24 VSUBS 0.02429f
C371 w_n1806_3170.t25 VSUBS 0.23134f
C372 w_n1806_3170.n347 VSUBS 0.05257f
C373 w_n1806_3170.n348 VSUBS 0.00229f
C374 w_n1806_3170.n349 VSUBS 0.00165f
C375 w_n1806_3170.n350 VSUBS 0.00229f
C376 w_n1806_3170.n351 VSUBS 0.00229f
C377 w_n1806_3170.n352 VSUBS 0.00229f
C378 w_n1806_3170.n353 VSUBS 0.00165f
C379 w_n1806_3170.t6 VSUBS 0.1441f
C380 w_n1806_3170.n354 VSUBS 0.00186f
C381 w_n1806_3170.n355 VSUBS 0.00165f
C382 w_n1806_3170.n356 VSUBS 0.00542f
C383 w_n1806_3170.n357 VSUBS 0.00229f
C384 w_n1806_3170.n358 VSUBS 0.00229f
C385 w_n1806_3170.n359 VSUBS 0.00229f
C386 w_n1806_3170.n360 VSUBS 0.00229f
C387 w_n1806_3170.n361 VSUBS 0.00165f
C388 w_n1806_3170.n362 VSUBS 0.00165f
C389 w_n1806_3170.n363 VSUBS 0.18553f
C390 w_n1806_3170.n364 VSUBS 0.00229f
C391 w_n1806_3170.n365 VSUBS 0.00165f
C392 w_n1806_3170.n366 VSUBS 0.00165f
C393 w_n1806_3170.n367 VSUBS 0.00229f
C394 w_n1806_3170.n368 VSUBS 0.00229f
C395 w_n1806_3170.t0 VSUBS 0.1441f
C396 w_n1806_3170.n369 VSUBS 0.00229f
C397 w_n1806_3170.n370 VSUBS 0.00229f
C398 w_n1806_3170.n371 VSUBS 0.00165f
C399 w_n1806_3170.n372 VSUBS 0.00229f
C400 w_n1806_3170.n373 VSUBS 0.00229f
C401 w_n1806_3170.n374 VSUBS 0.00165f
C402 w_n1806_3170.n375 VSUBS 0.00229f
C403 w_n1806_3170.n376 VSUBS 0.00229f
C404 w_n1806_3170.n377 VSUBS 0.00229f
C405 w_n1806_3170.n378 VSUBS 0.00229f
C406 w_n1806_3170.n379 VSUBS 0.00229f
C407 w_n1806_3170.n380 VSUBS 0.00165f
C408 w_n1806_3170.t2 VSUBS 0.1441f
C409 w_n1806_3170.n381 VSUBS 0.00165f
C410 w_n1806_3170.n382 VSUBS 0.00229f
C411 w_n1806_3170.n383 VSUBS 0.00229f
C412 w_n1806_3170.n384 VSUBS 0.00165f
C413 w_n1806_3170.n385 VSUBS 0.00229f
C414 w_n1806_3170.n386 VSUBS 0.00229f
C415 w_n1806_3170.n387 VSUBS 0.00165f
C416 w_n1806_3170.n388 VSUBS 0.20534f
C417 w_n1806_3170.n389 VSUBS 0.00165f
C418 w_n1806_3170.n390 VSUBS 0.00165f
C419 w_n1806_3170.n391 VSUBS 0.00229f
C420 w_n1806_3170.n392 VSUBS 0.00229f
C421 w_n1806_3170.n393 VSUBS 0.00165f
C422 w_n1806_3170.n394 VSUBS 0.16391f
C423 w_n1806_3170.n395 VSUBS 0.00165f
C424 w_n1806_3170.n396 VSUBS 0.00165f
C425 w_n1806_3170.n397 VSUBS 0.00229f
C426 w_n1806_3170.n398 VSUBS 0.00229f
C427 w_n1806_3170.n399 VSUBS 0.00229f
C428 w_n1806_3170.n400 VSUBS 0.00186f
C429 w_n1806_3170.n401 VSUBS 0.00542f
C430 w_n1806_3170.n402 VSUBS 0.02489f
C431 w_n1806_3170.n403 VSUBS 0.04281f
C432 w_n1806_3170.n404 VSUBS 0.01133f
C433 w_n1806_3170.n405 VSUBS 0.00186f
C434 w_n1806_3170.n406 VSUBS 0.01529f
C435 w_n1806_3170.n407 VSUBS 0.31342f
C436 w_n1806_3170.n408 VSUBS 0.95913f
C437 w_n1806_3170.n409 VSUBS 0.02832f
C438 w_n1806_3170.n410 VSUBS 0.04281f
C439 w_n1806_3170.n411 VSUBS 0.01133f
C440 w_n1806_3170.n412 VSUBS 0.00229f
C441 w_n1806_3170.n413 VSUBS 0.00229f
C442 w_n1806_3170.n414 VSUBS 0.00229f
C443 w_n1806_3170.n415 VSUBS 0.00229f
C444 w_n1806_3170.n416 VSUBS 0.00165f
C445 w_n1806_3170.n417 VSUBS 0.2882f
C446 w_n1806_3170.n418 VSUBS 0.00165f
C447 w_n1806_3170.n419 VSUBS 0.00229f
C448 w_n1806_3170.n420 VSUBS 0.00211f
C449 w_n1806_3170.n421 VSUBS 0.10874f
C450 w_n1806_3170.n422 VSUBS 0.10511f
C451 w_n1806_3170.n423 VSUBS 0.00229f
C452 w_n1806_3170.n424 VSUBS 0.00229f
C453 w_n1806_3170.n425 VSUBS 0.00165f
C454 w_n1806_3170.n426 VSUBS 0.16391f
C455 w_n1806_3170.n427 VSUBS 0.00165f
C456 w_n1806_3170.n428 VSUBS 0.00229f
C457 w_n1806_3170.n429 VSUBS 0.00229f
C458 w_n1806_3170.n430 VSUBS 0.00229f
C459 w_n1806_3170.n431 VSUBS 0.00229f
C460 w_n1806_3170.n432 VSUBS 0.00165f
C461 w_n1806_3170.n433 VSUBS 0.00229f
C462 w_n1806_3170.n434 VSUBS 0.00229f
C463 w_n1806_3170.n435 VSUBS 0.01529f
C464 w_n1806_3170.n436 VSUBS 0.00186f
C465 w_n1806_3170.n437 VSUBS 0.00542f
C466 w_n1806_3170.t22 VSUBS 0.02429f
C467 w_n1806_3170.t23 VSUBS 0.23134f
C468 w_n1806_3170.n438 VSUBS 0.05257f
C469 w_n1806_3170.n439 VSUBS 0.02489f
C470 w_n1806_3170.n440 VSUBS 0.04281f
C471 w_n1806_3170.n441 VSUBS 0.01133f
C472 w_n1806_3170.n442 VSUBS 0.01529f
C473 w_n1806_3170.n443 VSUBS 0.00186f
C474 w_n1806_3170.n444 VSUBS 0.00229f
C475 w_n1806_3170.n445 VSUBS 0.00229f
C476 w_n1806_3170.n446 VSUBS 0.00229f
C477 w_n1806_3170.n447 VSUBS 0.00165f
C478 w_n1806_3170.n448 VSUBS 0.26839f
C479 w_n1806_3170.n449 VSUBS 0.00165f
C480 w_n1806_3170.n450 VSUBS 0.00229f
C481 w_n1806_3170.n451 VSUBS 0.07246f
C482 w_n1806_3170.n452 VSUBS 0.00211f
C483 w_n1806_3170.n453 VSUBS 0.00229f
C484 w_n1806_3170.n454 VSUBS 0.00186f
C485 w_n1806_3170.n455 VSUBS 0.00229f
C486 w_n1806_3170.n456 VSUBS 0.00165f
C487 w_n1806_3170.n457 VSUBS 0.20354f
C488 w_n1806_3170.n458 VSUBS 0.00165f
C489 w_n1806_3170.n459 VSUBS 0.00229f
C490 w_n1806_3170.n460 VSUBS 0.00186f
C491 w_n1806_3170.n461 VSUBS 0.00542f
C492 w_n1806_3170.n462 VSUBS 0.02489f
C493 w_n1806_3170.n463 VSUBS 0.04281f
C494 w_n1806_3170.n464 VSUBS 0.02832f
C495 w_n1806_3170.n465 VSUBS 0.76103f
C496 w_n1806_3170.n466 VSUBS 3.27952f
C497 lna_block_62479d0d_0/Unnamed_3c60cbf2_0/a_n370_n2390# VSUBS 0.25367f
.ends
