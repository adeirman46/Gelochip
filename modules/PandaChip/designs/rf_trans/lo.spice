** sch_path: /home/irman/PandaChip/designs/rf_trans/lo.sch
**.subckt lo VDD 0 LO_P LO_N
*.ipin VDD
*.opin LO_P
*.opin LO_N
*.ipin 0
XM1 LO_P LO_N TAIL 0 nfet_03v3 L=0.28u W=50u nf=5 ad='int((nf+1)/2) * W/nf * 0.18u' as='int((nf+2)/2) * W/nf * 0.18u' pd='2*int((nf+1)/2) * (W/nf + 0.18u)'
+ ps='2*int((nf+2)/2) * (W/nf + 0.18u)' nrd='0.18u / W' nrs='0.18u / W' sa=0 sb=0 sd=0
XM2 LO_N LO_P TAIL 0 nfet_03v3 L=0.28u W=50u nf=5 ad='int((nf+1)/2) * W/nf * 0.18u' as='int((nf+2)/2) * W/nf * 0.18u' pd='2*int((nf+1)/2) * (W/nf + 0.18u)'
+ ps='2*int((nf+2)/2) * (W/nf + 0.18u)' nrd='0.18u / W' nrs='0.18u / W' sa=0 sb=0 sd=0
L1 VDD LO_P 100n
L2 VDD LO_N 100n
R1 VDD LO_P 2k
R2 VDD LO_N 2k
C1 LO_P 0 31.2p
C2 LO_N 0 31.2p
I1 TAIL 0 1m
**.ends
.end
