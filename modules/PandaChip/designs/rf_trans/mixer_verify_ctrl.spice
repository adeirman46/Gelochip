.title Mixer Verify
.include /foss/pdks/gf180mcuD/libs.tech/ngspice/design.ngspice
.lib /foss/pdks/gf180mcuD/libs.tech/ngspice/sm141064.ngspice typical

.subckt mixer VDD 0 RF_P RF_N LO_P LO_N IF_P IF_N
XM1 M1D RF_P TAIL 0 nfet_03v3 L=0.28u W=50u nf=5
XM2 M2D RF_N TAIL 0 nfet_03v3 L=0.28u W=50u nf=5
XM3 IF_P LO_P M1D 0 nfet_03v3 L=0.28u W=50u nf=5
XM4 IF_N LO_N M1D 0 nfet_03v3 L=0.28u W=50u nf=5
XM5 IF_P LO_N M2D 0 nfet_03v3 L=0.28u W=50u nf=5
XM6 IF_N LO_P M2D 0 nfet_03v3 L=0.28u W=50u nf=5
R1 VDD IF_P 2k
R2 VDD IF_N 2k
I1 TAIL 0 2m
.ends

X1 VDD 0 RF_P RF_N LO_P LO_N IF_P IF_N mixer
V1 VDD 0 3.3
V2 RF_P 0 SIN(1.5 0.1 100MEG)
V3 RF_N 0 SIN(1.5 0.1 100MEG 0 0 180)
V4 LO_P 0 SIN(2.2 1.0 90MEG)
V5 LO_N 0 SIN(2.2 1.0 90MEG 0 0 180)

.tran 1n 500n
.save all
.control
set filetype=binary
run
write mixer_verify.raw
.endc
