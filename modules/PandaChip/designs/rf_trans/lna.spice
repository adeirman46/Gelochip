** sch_path: /home/irman/PandaChip/designs/rf_trans/lna.sch
**.subckt lna VDD RF_IN RF_OUT 0
*.ipin VDD
*.ipin RF_IN
*.opin RF_OUT
*.ipin 0
XM1 MID VBIAS1 0 0 nfet_03v3 L=0.28u W=50u nf=5 ad='int((nf+1)/2) * W/nf * 0.18u' as='int((nf+2)/2) * W/nf * 0.18u' pd='2*int((nf+1)/2) * (W/nf + 0.18u)'
+ ps='2*int((nf+2)/2) * (W/nf + 0.18u)' nrd='0.18u / W' nrs='0.18u / W' sa=0 sb=0 sd=0
XM2 RF_OUT VBIAS2 MID 0 nfet_03v3 L=0.28u W=50u nf=5 ad='int((nf+1)/2) * W/nf * 0.18u' as='int((nf+2)/2) * W/nf * 0.18u' pd='2*int((nf+1)/2) * (W/nf + 0.18u)'
+ ps='2*int((nf+2)/2) * (W/nf + 0.18u)' nrd='0.18u / W' nrs='0.18u / W' sa=0 sb=0 sd=0
L1 VDD RF_OUT 100n
C1 VDD RF_OUT 25.3p
R_load VDD RF_OUT 2k
Cin VBIAS1 RF_IN 10p
R1 VDD VBIAS2 15k
R2 VBIAS2 0 18k
R3 VDD VBIAS1 25k
R4 VBIAS1 0 8k
**.ends
.end
