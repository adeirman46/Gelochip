** sch_path: /home/irman/PandaChip/designs/rf_trans/pa.sch
**.subckt pa VDD 0 RF_IN RF_OUT
*.ipin VDD
*.ipin RF_IN
*.opin RF_OUT
*.ipin 0
XM1 PA_D VBIAS 0 0 nfet_03v3 L=0.28u W=400u nf=40 ad='int((nf+1)/2) * W/nf * 0.18u' as='int((nf+2)/2) * W/nf * 0.18u' pd='2*int((nf+1)/2) * (W/nf + 0.18u)'
+ ps='2*int((nf+2)/2) * (W/nf + 0.18u)' nrd='0.18u / W' nrs='0.18u / W' sa=0 sb=0 sd=0
L1 VDD PA_D 1u
Cout RF_OUT PA_D 1n
Cin VBIAS RF_IN 100p
R1 VDD VBIAS 10k
R2 VBIAS 0 10k
**.ends
.end
