** sch_path: /home/irman/PandaChip/designs/iris-harvester/bias.sch
**.subckt bias VDD VBIAS
*.ipin VDD
*.opin VBIAS
I1 VDD VBIAS 1u
XM1 VBIAS VBIAS 0 0 nfet_03v3 L=0.28u W=10u nf=2 ad='int((nf+1)/2) * W/nf * 0.18u' as='int((nf+2)/2) * W/nf * 0.18u' pd='2*int((nf+1)/2) * (W/nf + 0.18u)'
+ ps='2*int((nf+2)/2) * (W/nf + 0.18u)' nrd='0.18u / W' nrs='0.18u / W' sa=0 sb=0 sd=0
**.ends
.end
