.subckt NMOS D G S B l=2.0 w=4.15
XMAIN1 D G S B nfet_03v3 l=2.0 w=4.15
XMAIN2 D G S B nfet_03v3 l=2.0 w=4.15
XDUMMY1 B B B B nfet_03v3 l=2.0 w=4.15
XDUMMY2 B B B B nfet_03v3 l=2.0 w=4.15
.ends NMOS

.subckt NMOS_1 D G S B l=2.0 w=1.42
XMAIN1 D G S B nfet_03v3 l=2.0 w=1.42
XDUMMY1 B B B B nfet_03v3 l=2.0 w=1.42
XDUMMY2 B B B B nfet_03v3 l=2.0 w=1.42
.ends NMOS_1

.subckt FLIPPED_VOLTAGE_FOLLOWER VIN VBULK VOUT Ib
X0 Ib VIN VOUT VBULK NMOS l=2.0 w=4.15
X1 VOUT Ib VBULK VBULK NMOS_1 l=2.0 w=1.42
.ends FLIPPED_VOLTAGE_FOLLOWER

.subckt NMOS D G S B l=2.0 w=4.15
XMAIN1 D G S B nfet_03v3 l=2.0 w=4.15
XMAIN2 D G S B nfet_03v3 l=2.0 w=4.15
XDUMMY1 B B B B nfet_03v3 l=2.0 w=4.15
XDUMMY2 B B B B nfet_03v3 l=2.0 w=4.15
.ends NMOS

.subckt FLIPPED_VOLTAGE_FOLLOWER VIN VBULK VOUT Ib
X0 Ib VIN VOUT VBULK NMOS l=2.0 w=4.15
X1 VOUT Ib VBULK VBULK NMOS l=2.0 w=4.15
.ends FLIPPED_VOLTAGE_FOLLOWER

.subckt NMOS D G S B l=2.0 w=4.15
XMAIN1 D G S B nfet_03v3 l=2.0 w=4.15
XMAIN2 D G S B nfet_03v3 l=2.0 w=4.15
XDUMMY1 B B B B nfet_03v3 l=2.0 w=4.15
XDUMMY2 B B B B nfet_03v3 l=2.0 w=4.15
.ends NMOS

.subckt Low_voltage_current_mirror IBIAS1 IBIAS2 GND IOUT1 IOUT2
X0 IBIAS1 GND local_net_1 IBIAS1 FLIPPED_VOLTAGE_FOLLOWER
X1 IBIAS1 GND local_net_2 IBIAS2 FLIPPED_VOLTAGE_FOLLOWER_1
X2 IOUT1 IBIAS1 wire0 GND NMOS l=2.0 w=4.15
X3 IOUT2 IBIAS1 wire1 GND NMOS l=2.0 w=4.15
X4 wire0 IBIAS2 GND GND NMOS l=2.0 w=4.15
X5 wire1 IBIAS2 GND GND NMOS l=2.0 w=4.15
.ends Low_voltage_current_mirror

.subckt two_trans_interdigitized VDD1 VDD2 VSS1 VSS2 VG1 VG2 VB l=1 w=2.25 m=1
XA VDD1 VG1 VSS1 VB nfet_03v3 l=1 w=2.25 m=2
XB VDD2 VG2 VSS2 VB nfet_03v3 l=1 w=2.25 m=2
XDUMMY VB VB VB VB nfet_03v3 l=1 w=2.25 m=2
.ends two_trans_interdigitized

.subckt CMIRROR VREF VOUT VSS B
X0 VREF VOUT VSS VSS VREF VREF B two_trans_interdigitized l=1 w=2.25 m={1}
.ends CMIRROR

.subckt NMOS D G S B l=2 w=4
XMAIN1 D G S B nfet_03v3 l=2 w=4
XDUMMY1 B B B B nfet_03v3 l=2 w=4
XDUMMY2 B B B B nfet_03v3 l=2 w=4
.ends NMOS

.subckt NMOS D G S B l=2.0 w=4.0
XMAIN1 D G S B nfet_03v3 l=2.0 w=4.0
XMAIN2 D G S B nfet_03v3 l=2.0 w=4.0
XDUMMY1 B B B B nfet_03v3 l=2.0 w=4.0
XDUMMY2 B B B B nfet_03v3 l=2.0 w=4.0
XDUMMY3 B B B B nfet_03v3 l=2.0 w=4.0
XDUMMY4 B B B B nfet_03v3 l=2.0 w=4.0
.ends NMOS

.subckt NMOS_1 D G S B l=1.0 w=2.75
XMAIN1 D G S B nfet_03v3 l=1.0 w=2.75
XMAIN2 D G S B nfet_03v3 l=1.0 w=2.75
XDUMMY1 B B B B nfet_03v3 l=1.0 w=2.75
XDUMMY2 B B B B nfet_03v3 l=1.0 w=2.75
XDUMMY3 B B B B nfet_03v3 l=1.0 w=2.75
XDUMMY4 B B B B nfet_03v3 l=1.0 w=2.75
.ends NMOS_1

.subckt FLIPPED_VOLTAGE_FOLLOWER VIN VBULK VOUT Ib
X0 Ib VIN VOUT VBULK NMOS l=2.0 w=4.0
X1 VOUT Ib VBULK VBULK NMOS_1 l=1.0 w=2.75
.ends FLIPPED_VOLTAGE_FOLLOWER

.subckt N_block IBIAS1 IBIAS2 GND ILCM1 ILCM2 IFVF1 IFVF2 INP INM Min1_D Min2_D OUT_N_1 OUT_N_2
X0 IBIAS1 IBIAS2 GND ILCM1 ILCM2 Low_voltage_current_mirror
X1 OUT_N_1 OUT_N_2 GND GND CMIRROR
X2 Min1_D INM S GND NMOS l=2 w=4
X3 Min2_D INP S GND NMOS l=2 w=4
X4 INM GND INP IFVF1 FLIPPED_VOLTAGE_FOLLOWER
X5 INP GND INM IFVF2 FLIPPED_VOLTAGE_FOLLOWER
.ends N_block
