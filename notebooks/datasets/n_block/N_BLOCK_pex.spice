* NGSPICE file created from N_BLOCK.ext - technology: gf180mcuC

.subckt N_BLOCK
X0 a_n9920_n10766# a_n9920_n10766# a_n9920_n10766# a_n9920_n10766# nfet_03v3 ad=2.32p pd=9.16u as=0.21549n ps=0.85932m w=4u l=2u
X1 a_n9920_n10766# a_n9920_n10766# a_n9920_n10766# a_n9920_n10766# nfet_03v3 ad=2.32p pd=9.16u as=0 ps=0 w=4u l=2u
X2 a_n9920_n10766# a_n5434_n10601# a_n2202_n10392# a_n9920_n10766# nfet_03v3 ad=2.49p pd=9.5u as=1.162p ps=4.71u w=4.15u l=2u
X3 a_n8386_n10392# a_n8786_n10601# a_n8906_n10392# a_n9920_n10766# nfet_03v3 ad=1.162p pd=4.71u as=2.49p ps=9.5u w=4.15u l=2u
X4 a_n9920_n10766# a_n9920_n10766# a_n9920_n10766# a_n9920_n10766# nfet_03v3 ad=2.32p pd=9.16u as=0 ps=0 w=4u l=2u
X5 a_n9920_n10766# a_n9920_n10766# a_n9920_n10766# a_n9920_n10766# nfet_03v3 ad=2.407p pd=9.46u as=0 ps=0 w=4.15u l=2u
X6 a_n9920_n10766# a_n9920_n10766# a_n9920_n10766# a_n9920_n10766# nfet_03v3 ad=2.407p pd=9.46u as=0 ps=0 w=4.15u l=2u
X7 a_n9920_n10766# a_n9920_n10766# a_n9920_n10766# a_n9920_n10766# nfet_03v3 ad=2.32p pd=9.16u as=0 ps=0 w=4u l=2u
X8 a_n9920_n10766# a_n9920_n10766# a_n9920_n10766# a_n9920_n10766# nfet_03v3 ad=2.32p pd=9.16u as=0 ps=0 w=4u l=2u
X9 a_n9920_n10766# a_n9920_n10766# a_n9920_n10766# a_n9920_n10766# nfet_03v3 ad=1.595p pd=6.66u as=0 ps=0 w=2.75u l=1u
X10 a_n9920_n10766# a_n9920_n10766# a_n9920_n10766# a_n9920_n10766# nfet_03v3 ad=1.305p pd=5.66u as=0 ps=0 w=2.25u l=1u
X11 a_n9920_n10766# a_n9920_n10766# a_n9920_n10766# a_n9920_n10766# nfet_03v3 ad=2.407p pd=9.46u as=0 ps=0 w=4.15u l=2u
X12 a_n9920_n10766# a_n9920_n10766# a_n9920_n10766# a_n9920_n10766# nfet_03v3 ad=1.595p pd=6.66u as=0 ps=0 w=2.75u l=1u
X13 a_n9920_n10766# a_n9920_n10766# a_n9920_n10766# a_n9920_n10766# nfet_03v3 ad=2.407p pd=9.46u as=0 ps=0 w=4.15u l=2u
X14 a_n9920_n10766# a_n9920_n10766# a_n9920_n10766# a_n9920_n10766# nfet_03v3 ad=2.32p pd=9.16u as=0 ps=0 w=4u l=2u
X15 a_4922_n10392# a_n5434_n10601# a_n9920_n10766# a_n9920_n10766# nfet_03v3 ad=1.162p pd=4.71u as=2.49p ps=9.5u w=4.15u l=2u
X16 a_n9920_n10766# a_1250_n889# a_n9920_n10766# a_n9920_n10766# nfet_03v3 ad=2.4p pd=9.2u as=0 ps=0 w=4u l=2u
X17 a_n9920_n10766# a_n9920_n10766# a_n9920_n10766# a_n9920_n10766# nfet_03v3 ad=1.595p pd=6.66u as=0 ps=0 w=2.75u l=1u
X18 a_n9920_n10766# a_n9920_n10766# a_n9920_n10766# a_n9920_n10766# nfet_03v3 ad=1.595p pd=6.66u as=0 ps=0 w=2.75u l=1u
X19 a_n9920_n10766# a_n9920_n10766# a_n9920_n10766# a_n9920_n10766# nfet_03v3 ad=2.407p pd=9.46u as=0 ps=0 w=4.15u l=2u
X20 a_n9920_n10766# a_n9920_n10766# a_n9920_n10766# a_n9920_n10766# nfet_03v3 ad=2.32p pd=9.16u as=0 ps=0 w=4u l=2u
X21 a_n9920_n10766# a_n9920_n10766# a_n9920_n10766# a_n9920_n10766# nfet_03v3 ad=0.8236p pd=4u as=0 ps=0 w=1.42u l=2u
X22 a_n9920_n10766# a_n9920_n10766# a_n9920_n10766# a_n9920_n10766# nfet_03v3 ad=1.595p pd=6.66u as=0 ps=0 w=2.75u l=1u
X23 a_n9920_n10766# a_n9920_n10766# a_n9920_n10766# a_n9920_n10766# nfet_03v3 ad=1.595p pd=6.66u as=0 ps=0 w=2.75u l=1u
X24 a_n9920_n10766# a_n9920_n10766# a_n9920_n10766# a_n9920_n10766# nfet_03v3 ad=1.305p pd=5.66u as=0 ps=0 w=2.25u l=1u
X25 a_n9920_n10766# a_n9920_n10766# a_n9920_n10766# a_n9920_n10766# nfet_03v3 ad=2.4041p pd=9.45u as=0 ps=0 w=4.145u l=2u
X26 a_n9920_n10766# a_n9920_n10766# a_n9920_n10766# a_n9920_n10766# nfet_03v3 ad=1.65p pd=6.7u as=0 ps=0 w=2.75u l=1u
X27 a_n8906_n10392# a_n5434_n10601# a_n9920_n10766# a_n9920_n10766# nfet_03v3 ad=1.162p pd=4.71u as=2.49p ps=9.5u w=4.15u l=2u
X28 a_n9920_n10766# a_n9920_n10766# a_n9920_n10766# a_n9920_n10766# nfet_03v3 ad=2.32p pd=9.16u as=0 ps=0 w=4u l=2u
X29 a_n9920_n10766# a_n9920_n10766# a_n9920_n10766# a_n9920_n10766# nfet_03v3 ad=2.32p pd=9.16u as=0 ps=0 w=4u l=2u
X30 a_n9920_n10766# a_1250_n889# a_n9920_n10766# a_n9920_n10766# nfet_03v3 ad=2.4p pd=9.2u as=0 ps=0 w=4u l=2u
X31 a_n195_n6940# a_n985_n7321# a_n9920_n10766# a_n9920_n10766# nfet_03v3 ad=1.35p pd=5.7u as=1.35p ps=5.7u w=2.25u l=1u
X32 a_n9920_n10766# a_n9920_n10766# a_n9920_n10766# a_n9920_n10766# nfet_03v3 ad=2.407p pd=9.46u as=0 ps=0 w=4.15u l=2u
X33 a_n9920_n10766# a_n9920_n10766# a_n9920_n10766# a_n9920_n10766# nfet_03v3 ad=2.407p pd=9.46u as=0 ps=0 w=4.15u l=2u
X34 a_4922_n10392# a_n8786_n10601# a_8274_n10392# a_n9920_n10766# nfet_03v3 ad=2.49p pd=9.5u as=1.162p ps=4.71u w=4.15u l=2u
X35 a_n576_n14232# a_n8786_n10601# a_n8786_n10601# a_n9920_n10766# nfet_03v3 ad=2.487p pd=9.49u as=1.1606p ps=4.705u w=4.145u l=2u
X36 a_n9920_n10766# a_n9920_n10766# a_n9920_n10766# a_n9920_n10766# nfet_03v3 ad=2.407p pd=9.46u as=0 ps=0 w=4.15u l=2u
X37 a_n9920_n10766# a_n5484_n1513# a_n9920_n10766# a_n9920_n10766# nfet_03v3 ad=2.4p pd=9.2u as=0 ps=0 w=4u l=2u
X38 a_n9920_n10766# a_n9920_n10766# a_n9920_n10766# a_n9920_n10766# nfet_03v3 ad=2.32p pd=9.16u as=0 ps=0 w=4u l=2u
X39 a_n9920_n10766# a_n9920_n10766# a_n9920_n10766# a_n9920_n10766# nfet_03v3 ad=2.407p pd=9.46u as=0 ps=0 w=4.15u l=2u
X40 a_n9920_n10766# a_n9920_n10766# a_n9920_n10766# a_n9920_n10766# nfet_03v3 ad=0.8236p pd=4u as=0 ps=0 w=1.42u l=2u
X41 a_n9920_n10766# a_n9920_n10766# a_n9920_n10766# a_n9920_n10766# nfet_03v3 ad=1.595p pd=6.66u as=0 ps=0 w=2.75u l=1u
X42 a_n985_n7321# a_n985_n7321# a_n9920_n10766# a_n9920_n10766# nfet_03v3 ad=1.35p pd=5.7u as=1.35p ps=5.7u w=2.25u l=1u
X43 a_n9920_n10766# a_n9920_n10766# a_n9920_n10766# a_n9920_n10766# nfet_03v3 ad=2.407p pd=9.46u as=0 ps=0 w=4.15u l=2u
X44 a_n9920_n10766# a_n9920_n10766# a_n9920_n10766# a_n9920_n10766# nfet_03v3 ad=1.65p pd=6.7u as=0 ps=0 w=2.75u l=1u
X45 a_n9920_n10766# a_n9920_n10766# a_n9920_n10766# a_n9920_n10766# nfet_03v3 ad=2.407p pd=9.46u as=0 ps=0 w=4.15u l=2u
X46 a_n9920_n10766# a_n5434_n10601# a_n8906_n10392# a_n9920_n10766# nfet_03v3 ad=2.49p pd=9.5u as=1.162p ps=4.71u w=4.15u l=2u
X47 a_n2202_n10392# a_n5434_n10601# a_n9920_n10766# a_n9920_n10766# nfet_03v3 ad=1.162p pd=4.71u as=2.49p ps=9.5u w=4.15u l=2u
X48 a_n9920_n10766# a_n9920_n10766# a_n9920_n10766# a_n9920_n10766# nfet_03v3 ad=2.4041p pd=9.45u as=0 ps=0 w=4.145u l=2u
X49 a_n9920_n10766# a_n9920_n10766# a_n9920_n10766# a_n9920_n10766# nfet_03v3 ad=2.32p pd=9.16u as=0 ps=0 w=4u l=2u
X50 a_n8906_n10392# a_n8786_n10601# a_n8386_n10392# a_n9920_n10766# nfet_03v3 ad=2.49p pd=9.5u as=1.162p ps=4.71u w=4.15u l=2u
X51 a_n9920_n10766# a_n5484_n1513# a_n9920_n10766# a_n9920_n10766# nfet_03v3 ad=2.4p pd=9.2u as=0 ps=0 w=4u l=2u
X52 a_8274_n10392# a_n8786_n10601# a_4922_n10392# a_n9920_n10766# nfet_03v3 ad=1.162p pd=4.71u as=2.49p ps=9.5u w=4.15u l=2u
X53 a_n8786_n10601# a_n8786_n10601# a_n576_n14232# a_n9920_n10766# nfet_03v3 ad=1.1606p pd=4.705u as=2.487p ps=9.49u w=4.145u l=2u
X54 a_n576_n14232# a_n8786_n10601# a_n9920_n10766# a_n9920_n10766# nfet_03v3 ad=0.852p pd=4.04u as=0.852p ps=4.04u w=1.42u l=2u
X55 a_n9920_n10766# a_n9920_n10766# a_n9920_n10766# a_n9920_n10766# nfet_03v3 ad=1.65p pd=6.7u as=0 ps=0 w=2.75u l=1u
X56 a_n985_n7321# a_n985_n7321# a_n9920_n10766# a_n9920_n10766# nfet_03v3 ad=1.35p pd=5.7u as=1.35p ps=5.7u w=2.25u l=1u
X57 a_n9920_n10766# a_n9920_n10766# a_n9920_n10766# a_n9920_n10766# nfet_03v3 ad=2.407p pd=9.46u as=0 ps=0 w=4.15u l=2u
X58 a_n2202_n10392# a_n8786_n10601# a_n5434_n10601# a_n9920_n10766# nfet_03v3 ad=2.49p pd=9.5u as=1.162p ps=4.71u w=4.15u l=2u
X59 a_n9920_n10766# a_n9920_n10766# a_n9920_n10766# a_n9920_n10766# nfet_03v3 ad=1.595p pd=6.66u as=0 ps=0 w=2.75u l=1u
X60 a_n9920_n10766# a_n9920_n10766# a_n9920_n10766# a_n9920_n10766# nfet_03v3 ad=2.32p pd=9.16u as=0 ps=0 w=4u l=2u
X61 a_n195_n6940# a_n985_n7321# a_n9920_n10766# a_n9920_n10766# nfet_03v3 ad=1.35p pd=5.7u as=1.35p ps=5.7u w=2.25u l=1u
X62 a_n9920_n10766# a_n5434_n10601# a_4922_n10392# a_n9920_n10766# nfet_03v3 ad=2.49p pd=9.5u as=1.162p ps=4.71u w=4.15u l=2u
X63 a_n9920_n10766# a_n9920_n10766# a_n9920_n10766# a_n9920_n10766# nfet_03v3 ad=1.65p pd=6.7u as=0 ps=0 w=2.75u l=1u
X64 a_n5434_n10601# a_n8786_n10601# a_n2202_n10392# a_n9920_n10766# nfet_03v3 ad=1.162p pd=4.71u as=2.49p ps=9.5u w=4.15u l=2u
X65 a_n1250_n681# a_n5484_n1513# a_n9920_n10766# a_n9920_n10766# nfet_03v3 ad=2.4p pd=9.2u as=2.4p ps=9.2u w=4u l=2u
X66 a_1650_n681# a_1250_n889# a_n9920_n10766# a_n9920_n10766# nfet_03v3 ad=2.4p pd=9.2u as=2.4p ps=9.2u w=4u l=2u
C0 a_8274_n10392# a_n8786_n10601# 0.49038f
C1 a_n5434_n10601# a_n8906_n10392# 0.49993f
C2 a_4922_n10392# a_8274_n10392# 0.96303f
C3 a_n5434_n10601# a_n576_n14232# 0.22831f
C4 a_n8386_n10392# a_n8786_n10601# 0.49038f
C5 a_n985_n7321# a_n2202_n10392# 0.00445f
C6 a_n8786_n10601# a_n8906_n10392# 0.57666f
C7 a_n576_n14232# a_n8786_n10601# 2.23385f
C8 a_1250_n889# a_1650_n681# 0.23623f
C9 a_n5434_n10601# a_n2202_n10392# 1.45944f
C10 a_n5434_n10601# a_n8786_n10601# 6.19812f
C11 a_4922_n10392# a_n5434_n10601# 0.49589f
C12 a_n1250_n681# a_n5484_n1513# 0.20168f
C13 a_n8386_n10392# a_n8906_n10392# 0.95874f
C14 a_n2202_n10392# a_n8786_n10601# 0.57845f
C15 a_n985_n7321# a_n195_n6940# 0.50717f
C16 a_4922_n10392# a_n8786_n10601# 0.57666f
C17 a_n576_n14232# a_n9920_n10766# 4.09722f
C18 a_8274_n10392# a_n9920_n10766# 0.74184f
C19 a_4922_n10392# a_n9920_n10766# 4.72686f
C20 a_n2202_n10392# a_n9920_n10766# 4.63682f
C21 a_n5434_n10601# a_n9920_n10766# 16.1944f
C22 a_n8386_n10392# a_n9920_n10766# 0.74184f
C23 a_n8906_n10392# a_n9920_n10766# 4.71883f
C24 a_n8786_n10601# a_n9920_n10766# 26.9603f
C25 a_n195_n6940# a_n9920_n10766# 5.44864f
C26 a_n985_n7321# a_n9920_n10766# 10.4781f
C27 a_1650_n681# a_n9920_n10766# 1.75116f
C28 a_1250_n889# a_n9920_n10766# 9.23341f
C29 a_n1250_n681# a_n9920_n10766# 1.74849f
C30 a_n5484_n1513# a_n9920_n10766# 9.2681f
.ends
