* NGSPICE file created from OTA.ext - technology: gf180mcuC

.subckt OTA
X0 a_n17074_11107# a_n17074_11107# a_n17074_11107# a_n17074_11107# nfet_03v3 ad=2.407p pd=9.46u as=0.22511n ps=0.90502m w=4.15u l=2u
X1 a_n17074_11107# a_n17074_11107# a_n17074_11107# a_n17074_11107# nfet_03v3 ad=2.407p pd=9.46u as=0 ps=0 w=4.15u l=2u
X2 a_n17074_11107# a_n17074_11107# a_n17074_11107# a_n17074_11107# nfet_03v3 ad=2.407p pd=9.46u as=0 ps=0 w=4.15u l=2u
X3 a_n985_n255# a_n985_n255# a_n17074_11107# a_n17074_11107# nfet_03v3 ad=1.35p pd=5.7u as=1.35p ps=5.7u w=2.25u l=1u
X4 a_n17074_11107# a_n17074_11107# a_n17074_11107# a_n17074_11107# nfet_03v3 ad=2.32p pd=9.16u as=0 ps=0 w=4u l=2u
X5 a_n17074_11107# a_n17074_11107# a_n17074_11107# a_n17074_11107# nfet_03v3 ad=0.8236p pd=4u as=0 ps=0 w=1.42u l=2u
X6 a_n985_n255# a_n3510_10663# w_n18368_10435# w_n18368_10435# pfet_03v3 ad=2.7p pd=10.2u as=2.7p ps=10.2u w=4.5u l=1u
X7 a_n3510_10663# a_n2590_10663# w_n18368_10435# w_n18368_10435# pfet_03v3 ad=2.7p pd=10.2u as=2.7p ps=10.2u w=4.5u l=1u
X8 a_n17074_11107# a_n17074_11107# a_n17074_11107# a_n17074_11107# nfet_03v3 ad=2.407p pd=9.46u as=0 ps=0 w=4.15u l=2u
X9 a_n576_n7166# a_n8786_n3535# a_n17074_11107# a_n17074_11107# nfet_03v3 ad=0.852p pd=4.04u as=0.852p ps=4.04u w=1.42u l=2u
X10 a_n576_n7166# a_n8786_n3535# a_n8786_n3535# a_n17074_11107# nfet_03v3 ad=2.487p pd=9.49u as=1.1606p ps=4.705u w=4.145u l=2u
X11 a_n17074_11107# a_n17074_11107# a_n17074_11107# a_n17074_11107# nfet_03v3 ad=2.407p pd=9.46u as=0 ps=0 w=4.15u l=2u
X12 a_n17074_11107# a_n17074_11107# a_n17074_11107# a_n17074_11107# nfet_03v3 ad=0.29p pd=2.16u as=0 ps=0 w=0.5u l=4u
X13 a_n17074_11107# a_n17074_11107# a_n17074_11107# a_n17074_11107# nfet_03v3 ad=0.8236p pd=4u as=0 ps=0 w=1.42u l=2u
X14 a_n17074_11107# a_n17074_11107# a_n17074_11107# a_n17074_11107# nfet_03v3 ad=2.32p pd=9.16u as=0 ps=0 w=4u l=2u
X15 a_n17074_11107# a_n5484_5553# a_n17074_11107# a_n17074_11107# nfet_03v3 ad=2.4p pd=9.2u as=0 ps=0 w=4u l=2u
X16 a_n17074_11107# a_n17074_11107# a_n17074_11107# a_n17074_11107# nfet_03v3 ad=2.407p pd=9.46u as=0 ps=0 w=4.15u l=2u
X17 a_n17074_11107# a_n17074_11107# a_n17074_11107# a_n17074_11107# nfet_03v3 ad=2.407p pd=9.46u as=0 ps=0 w=4.15u l=2u
X18 a_n17074_11107# a_n17074_11107# a_n17074_11107# a_n17074_11107# nfet_03v3 ad=1.65p pd=6.7u as=0 ps=0 w=2.75u l=1u
X19 a_n17074_11107# a_n17074_11107# a_n17074_11107# a_n17074_11107# nfet_03v3 ad=0.29p pd=2.16u as=0 ps=0 w=0.5u l=4u
X20 a_n395_19083# a_n2590_10663# w_n18368_10435# w_n18368_10435# pfet_03v3 ad=2.7p pd=10.2u as=2.7p ps=10.2u w=4.5u l=1u
X21 a_n17074_11107# a_n17074_11107# a_n17074_11107# a_n17074_11107# nfet_03v3 ad=2.32p pd=9.16u as=0 ps=0 w=4u l=2u
X22 a_4922_n3326# a_n8786_n3535# w_n18368_10435# a_n17074_11107# nfet_03v3 ad=2.49p pd=9.5u as=1.162p ps=4.71u w=4.15u l=2u
X23 a_n17074_11107# a_n17074_11107# a_n17074_11107# a_n17074_11107# nfet_03v3 ad=2.32p pd=9.16u as=0 ps=0 w=4u l=2u
X24 w_n18368_10435# w_n18368_10435# w_n18368_10435# w_n18368_10435# pfet_03v3 ad=1.0904p pd=4.92u as=78.65919p ps=0.31904m w=1.88u l=3u
X25 a_n985_n255# a_n3510_10663# w_n18368_10435# w_n18368_10435# pfet_03v3 ad=2.7p pd=10.2u as=2.7p ps=10.2u w=4.5u l=1u
X26 a_n17074_11107# a_n17074_11107# a_n17074_11107# a_n17074_11107# nfet_03v3 ad=2.407p pd=9.46u as=0 ps=0 w=4.15u l=2u
X27 a_n17074_11107# a_n17074_11107# a_n17074_11107# a_n17074_11107# nfet_03v3 ad=2.4041p pd=9.45u as=0 ps=0 w=4.145u l=2u
X28 a_n17074_11107# a_n17074_11107# a_n17074_11107# a_n17074_11107# nfet_03v3 ad=2.32p pd=9.16u as=0 ps=0 w=4u l=2u
X29 a_n17074_11107# a_n17074_11107# a_n17074_11107# a_n17074_11107# nfet_03v3 ad=2.407p pd=9.46u as=0 ps=0 w=4.15u l=2u
X30 a_n985_n255# a_n985_n255# a_n17074_11107# a_n17074_11107# nfet_03v3 ad=1.35p pd=5.7u as=1.35p ps=5.7u w=2.25u l=1u
X31 a_n395_19083# a_1250_6177# a_n17074_11107# a_n17074_11107# nfet_03v3 ad=2.4p pd=9.2u as=2.4p ps=9.2u w=4u l=2u
X32 a_n17074_11107# a_n17074_11107# a_n17074_11107# a_n17074_11107# nfet_03v3 ad=1.595p pd=6.66u as=0 ps=0 w=2.75u l=1u
X33 a_n5434_n3535# a_n8786_n3535# a_n17074_11107# a_n17074_11107# nfet_03v3 ad=1.162p pd=4.71u as=2.49p ps=9.5u w=4.15u l=2u
X34 a_n3510_10663# a_n5484_5553# a_n17074_11107# a_n17074_11107# nfet_03v3 ad=2.4p pd=9.2u as=2.4p ps=9.2u w=4u l=2u
X35 a_n17074_11107# w_n18368_10435# w_n18368_10435# w_n18368_10435# pfet_03v3 ad=1.128p pd=4.96u as=1.128p ps=4.96u w=1.88u l=3u
X36 a_n17074_11107# a_n5434_n3535# a_n17074_11107# a_n17074_11107# nfet_03v3 ad=1.162p pd=4.71u as=0 ps=0 w=4.15u l=2u
X37 w_n18368_10435# w_n18368_10435# w_n18368_10435# w_n18368_10435# pfet_03v3 ad=1.74p pd=7.16u as=0 ps=0 w=3u l=4u
X38 w_n18368_10435# a_n8786_n3535# a_n8906_n3326# a_n17074_11107# nfet_03v3 ad=1.162p pd=4.71u as=2.49p ps=9.5u w=4.15u l=2u
X39 a_n17074_11107# a_n17074_11107# a_n17074_11107# a_n17074_11107# nfet_03v3 ad=2.4041p pd=9.45u as=0 ps=0 w=4.145u l=2u
X40 a_n195_126# a_n395_19083# w_n18368_10435# w_n18368_10435# pfet_03v3 ad=2.7p pd=10.2u as=2.7p ps=10.2u w=4.5u l=1u
X41 w_n18368_10435# w_n18368_10435# w_n18368_10435# w_n18368_10435# pfet_03v3 ad=1.74p pd=7.16u as=0 ps=0 w=3u l=4u
X42 w_n18368_10435# w_n18368_10435# w_n18368_10435# w_n18368_10435# pfet_03v3 ad=1.0904p pd=4.92u as=0 ps=0 w=1.88u l=3u
X43 a_n17074_11107# a_n5434_n3535# a_4922_n3326# a_n17074_11107# nfet_03v3 ad=2.49p pd=9.5u as=1.162p ps=4.71u w=4.15u l=2u
X44 w_n18368_10435# w_n18368_10435# w_n18368_10435# w_n18368_10435# pfet_03v3 ad=2.61p pd=10.16u as=0 ps=0 w=4.5u l=1u
X45 a_n17074_11107# a_n17074_11107# a_n17074_11107# a_n17074_11107# nfet_03v3 ad=1.305p pd=5.66u as=0 ps=0 w=2.25u l=1u
X46 a_n17074_11107# a_n17074_11107# a_n17074_11107# a_n17074_11107# nfet_03v3 ad=2.32p pd=9.16u as=0 ps=0 w=4u l=2u
X47 w_n18368_10435# w_n18368_10435# a_n17074_11107# w_n18368_10435# pfet_03v3 ad=1.128p pd=4.96u as=1.128p ps=4.96u w=1.88u l=3u
X48 a_n17074_11107# a_n17074_11107# a_n17074_11107# a_n17074_11107# nfet_03v3 ad=1.65p pd=6.7u as=0 ps=0 w=2.75u l=1u
X49 a_n17074_11107# a_n17074_11107# a_n17074_11107# a_n17074_11107# nfet_03v3 ad=1.595p pd=6.66u as=0 ps=0 w=2.75u l=1u
X50 a_n17074_11107# a_n17074_11107# a_n17074_11107# a_n17074_11107# nfet_03v3 ad=1.65p pd=6.7u as=0 ps=0 w=2.75u l=1u
X51 a_n8906_n3326# a_n5434_n3535# a_n17074_11107# a_n17074_11107# nfet_03v3 ad=1.162p pd=4.71u as=2.49p ps=9.5u w=4.15u l=2u
X52 w_n18368_10435# w_n18368_10435# w_n18368_10435# w_n18368_10435# pfet_03v3 ad=1.128p pd=4.96u as=0 ps=0 w=1.88u l=3u
X53 a_n17074_11107# a_n17074_11107# a_n17074_11107# a_n17074_11107# nfet_03v3 ad=1.595p pd=6.66u as=0 ps=0 w=2.75u l=1u
X54 a_n17074_11107# a_1250_6177# a_n17074_11107# a_n17074_11107# nfet_03v3 ad=2.4p pd=9.2u as=0 ps=0 w=4u l=2u
X55 a_n17074_11107# a_n17074_11107# a_n17074_11107# a_n17074_11107# nfet_03v3 ad=1.305p pd=5.66u as=0 ps=0 w=2.25u l=1u
X56 a_n17074_11107# a_n17074_11107# a_n17074_11107# a_n17074_11107# nfet_03v3 ad=2.32p pd=9.16u as=0 ps=0 w=4u l=2u
X57 a_n17074_11107# a_n17074_11107# a_n17074_11107# a_n17074_11107# nfet_03v3 ad=1.595p pd=6.66u as=0 ps=0 w=2.75u l=1u
X58 a_n195_126# a_n985_n255# a_n17074_11107# a_n17074_11107# nfet_03v3 ad=1.35p pd=5.7u as=1.35p ps=5.7u w=2.25u l=1u
X59 a_n17074_11107# a_n17074_11107# a_n17074_11107# a_n17074_11107# nfet_03v3 ad=0.29p pd=2.16u as=0 ps=0 w=0.5u l=4u
X60 w_n18368_10435# w_n18368_10435# w_n18368_10435# w_n18368_10435# pfet_03v3 ad=2.61p pd=10.16u as=0 ps=0 w=4.5u l=1u
X61 w_n18368_10435# w_n18368_10435# w_n18368_10435# w_n18368_10435# pfet_03v3 ad=1.128p pd=4.96u as=0 ps=0 w=1.88u l=3u
X62 a_n2590_10663# w_n18368_10435# a_n3510_10663# a_n17074_11107# nfet_03v3 ad=0.3p pd=2.2u as=0.3p ps=2.2u w=0.5u l=4u
X63 a_n17074_11107# a_n5434_n3535# a_n17074_11107# a_n17074_11107# nfet_03v3 ad=2.49p pd=9.5u as=0 ps=0 w=4.15u l=2u
X64 w_n18368_10435# w_n18368_10435# w_n18368_10435# w_n18368_10435# pfet_03v3 ad=1.128p pd=4.96u as=0 ps=0 w=1.88u l=3u
X65 a_n8906_n3326# a_n8786_n3535# w_n18368_10435# a_n17074_11107# nfet_03v3 ad=2.49p pd=9.5u as=1.162p ps=4.71u w=4.15u l=2u
X66 a_n17074_11107# a_n17074_11107# a_n17074_11107# a_n17074_11107# nfet_03v3 ad=2.32p pd=9.16u as=0 ps=0 w=4u l=2u
X67 w_n18368_10435# w_n18368_10435# w_n18368_10435# w_n18368_10435# pfet_03v3 ad=1.0904p pd=4.92u as=0 ps=0 w=1.88u l=3u
X68 w_n18368_10435# a_n8786_n3535# a_4922_n3326# a_n17074_11107# nfet_03v3 ad=1.162p pd=4.71u as=2.49p ps=9.5u w=4.15u l=2u
X69 a_n8786_n3535# a_n8786_n3535# a_n576_n7166# a_n17074_11107# nfet_03v3 ad=1.1606p pd=4.705u as=2.487p ps=9.49u w=4.145u l=2u
X70 a_n17074_11107# w_n18368_10435# w_n18368_10435# w_n18368_10435# pfet_03v3 ad=1.128p pd=4.96u as=1.128p ps=4.96u w=1.88u l=3u
X71 w_n18368_10435# w_n18368_10435# w_n18368_10435# w_n18368_10435# pfet_03v3 ad=2.61p pd=10.16u as=0 ps=0 w=4.5u l=1u
X72 a_n17074_11107# a_n17074_11107# a_n17074_11107# a_n17074_11107# nfet_03v3 ad=1.595p pd=6.66u as=0 ps=0 w=2.75u l=1u
X73 a_n17074_11107# a_n17074_11107# a_n17074_11107# a_n17074_11107# nfet_03v3 ad=1.65p pd=6.7u as=0 ps=0 w=2.75u l=1u
X74 a_n17074_11107# a_n17074_11107# a_n17074_11107# a_n17074_11107# nfet_03v3 ad=1.595p pd=6.66u as=0 ps=0 w=2.75u l=1u
X75 a_n395_19083# w_n18368_10435# a_n2590_10663# a_n17074_11107# nfet_03v3 ad=0.3p pd=2.2u as=0.3p ps=2.2u w=0.5u l=4u
X76 a_n195_126# a_n985_n255# a_n17074_11107# a_n17074_11107# nfet_03v3 ad=1.35p pd=5.7u as=1.35p ps=5.7u w=2.25u l=1u
X77 a_n17074_11107# a_n17074_11107# a_n17074_11107# a_n17074_11107# nfet_03v3 ad=2.407p pd=9.46u as=0 ps=0 w=4.15u l=2u
X78 a_n17074_11107# a_n17074_11107# a_n17074_11107# a_n17074_11107# nfet_03v3 ad=0.29p pd=2.16u as=0 ps=0 w=0.5u l=4u
X79 w_n18368_10435# w_n18368_10435# w_n18368_10435# w_n18368_10435# pfet_03v3 ad=1.74p pd=7.16u as=0 ps=0 w=3u l=4u
X80 w_n18368_10435# w_n18368_10435# w_n18368_10435# w_n18368_10435# pfet_03v3 ad=1.0904p pd=4.92u as=0 ps=0 w=1.88u l=3u
X81 a_n17074_11107# a_n17074_11107# a_n17074_11107# a_n17074_11107# nfet_03v3 ad=2.32p pd=9.16u as=0 ps=0 w=4u l=2u
X82 a_n2590_10663# a_n17074_11107# a_n3510_10663# w_n18368_10435# pfet_03v3 ad=1.8p pd=7.2u as=1.8p ps=7.2u w=3u l=4u
X83 a_n17074_11107# a_n17074_11107# a_n17074_11107# a_n17074_11107# nfet_03v3 ad=1.595p pd=6.66u as=0 ps=0 w=2.75u l=1u
X84 w_n18368_10435# w_n18368_10435# a_n17074_11107# w_n18368_10435# pfet_03v3 ad=1.128p pd=4.96u as=1.128p ps=4.96u w=1.88u l=3u
X85 a_n395_19083# a_n2590_10663# w_n18368_10435# w_n18368_10435# pfet_03v3 ad=2.7p pd=10.2u as=2.7p ps=10.2u w=4.5u l=1u
X86 a_4922_n3326# a_n5434_n3535# a_n17074_11107# a_n17074_11107# nfet_03v3 ad=1.162p pd=4.71u as=2.49p ps=9.5u w=4.15u l=2u
X87 a_n17074_11107# a_n17074_11107# a_n17074_11107# a_n17074_11107# nfet_03v3 ad=2.32p pd=9.16u as=0 ps=0 w=4u l=2u
X88 a_n17074_11107# a_n5484_5553# a_n17074_11107# a_n17074_11107# nfet_03v3 ad=2.4p pd=9.2u as=0 ps=0 w=4u l=2u
X89 a_n17074_11107# a_n17074_11107# a_n17074_11107# a_n17074_11107# nfet_03v3 ad=2.407p pd=9.46u as=0 ps=0 w=4.15u l=2u
X90 a_n17074_11107# a_n17074_11107# a_n17074_11107# a_n17074_11107# nfet_03v3 ad=2.407p pd=9.46u as=0 ps=0 w=4.15u l=2u
X91 w_n18368_10435# w_n18368_10435# w_n18368_10435# w_n18368_10435# pfet_03v3 ad=2.61p pd=10.16u as=0 ps=0 w=4.5u l=1u
X92 a_n17074_11107# a_1250_6177# a_n17074_11107# a_n17074_11107# nfet_03v3 ad=2.4p pd=9.2u as=0 ps=0 w=4u l=2u
X93 a_n17074_11107# a_n5434_n3535# a_n8906_n3326# a_n17074_11107# nfet_03v3 ad=2.49p pd=9.5u as=1.162p ps=4.71u w=4.15u l=2u
X94 a_n3510_10663# a_n2590_10663# w_n18368_10435# w_n18368_10435# pfet_03v3 ad=2.7p pd=10.2u as=2.7p ps=10.2u w=4.5u l=1u
X95 a_n17074_11107# a_n17074_11107# a_n17074_11107# a_n17074_11107# nfet_03v3 ad=2.32p pd=9.16u as=0 ps=0 w=4u l=2u
X96 a_n395_19083# a_n17074_11107# a_n2590_10663# w_n18368_10435# pfet_03v3 ad=1.8p pd=7.2u as=1.8p ps=7.2u w=3u l=4u
X97 a_n17074_11107# a_n17074_11107# a_n17074_11107# a_n17074_11107# nfet_03v3 ad=2.32p pd=9.16u as=0 ps=0 w=4u l=2u
X98 w_n18368_10435# w_n18368_10435# w_n18368_10435# w_n18368_10435# pfet_03v3 ad=1.74p pd=7.16u as=0 ps=0 w=3u l=4u
X99 a_n17074_11107# a_n17074_11107# a_n17074_11107# a_n17074_11107# nfet_03v3 ad=1.595p pd=6.66u as=0 ps=0 w=2.75u l=1u
X100 a_n17074_11107# a_n8786_n3535# a_n5434_n3535# a_n17074_11107# nfet_03v3 ad=2.49p pd=9.5u as=1.162p ps=4.71u w=4.15u l=2u
X101 a_n195_126# a_n395_19083# w_n18368_10435# w_n18368_10435# pfet_03v3 ad=2.7p pd=10.2u as=2.7p ps=10.2u w=4.5u l=1u
X102 w_n18368_10435# w_n18368_10435# w_n18368_10435# w_n18368_10435# pfet_03v3 ad=1.128p pd=4.96u as=0 ps=0 w=1.88u l=3u
C0 a_n5484_5553# w_n18368_10435# 0.1071f
C1 a_n395_19083# a_n2590_10663# 2.32302f
C2 a_n8786_n3535# a_n8906_n3326# 0.57666f
C3 a_4922_n3326# w_n18368_10435# 0.96444f
C4 a_n985_n255# w_n18368_10435# 8.09494f
C5 a_n195_126# a_n3510_10663# 0.03579f
C6 a_n5434_n3535# a_n576_n7166# 0.22831f
C7 a_n3510_10663# a_n395_19083# 1.08841f
C8 a_n3510_10663# a_n2590_10663# 2.36914f
C9 a_n8786_n3535# a_n5434_n3535# 6.36762f
C10 a_4922_n3326# a_n8786_n3535# 0.57666f
C11 a_n195_126# a_n5484_5553# 0.01982f
C12 a_n8786_n3535# w_n18368_10435# 0.99938f
C13 a_n195_126# a_n985_n255# 1.83848f
C14 a_n195_126# w_n18368_10435# 8.10867f
C15 a_n395_19083# a_n985_n255# 0.00557f
C16 a_1250_6177# w_n18368_10435# 0.1071f
C17 a_n395_19083# w_n18368_10435# 12.1478f
C18 a_n8786_n3535# a_n576_n7166# 2.23436f
C19 a_n2590_10663# w_n18368_10435# 12.0777f
C20 a_n3510_10663# a_n5484_5553# 0.20168f
C21 a_n8906_n3326# a_n5434_n3535# 0.49993f
C22 a_n3510_10663# a_n985_n255# 0.37086f
C23 a_n3510_10663# w_n18368_10435# 12.0171f
C24 a_n8906_n3326# w_n18368_10435# 0.96f
C25 a_n8786_n3535# m3_n4013_n12261# 0.09221f
C26 a_n195_126# a_1250_6177# 0.41891f
C27 a_n195_126# a_n395_19083# 0.3148f
C28 a_4922_n3326# a_n5434_n3535# 0.73635f
C29 a_n985_n255# a_n5434_n3535# 0.00838f
C30 a_n395_19083# a_1250_6177# 0.23623f
C31 a_n985_n255# a_n5484_5553# 0.41891f
C32 a_n5434_n3535# w_n18368_10435# 0.20303f
C33 m3_n4013_n12261# a_n17074_11107# 0.09597f $ **FLOATING
C34 a_n576_n7166# a_n17074_11107# 4.09614f
C35 a_4922_n3326# a_n17074_11107# 5.25459f
C36 a_n5434_n3535# a_n17074_11107# 25.6285f
C37 a_n8906_n3326# a_n17074_11107# 4.71745f
C38 a_n8786_n3535# a_n17074_11107# 30.778f
C39 a_1250_6177# a_n17074_11107# 14.8584f
C40 a_n5484_5553# a_n17074_11107# 14.8931f
C41 a_n2590_10663# a_n17074_11107# 5.18518f
C42 a_n195_126# a_n17074_11107# 33.9668f
C43 a_n985_n255# a_n17074_11107# 28.706f
C44 a_n395_19083# a_n17074_11107# 8.11931f
C45 a_n3510_10663# a_n17074_11107# 7.8267f
C46 w_n18368_10435# a_n17074_11107# 0.28308p
.ends
