* NGSPICE file created from rx_frontend.ext - technology: gf180mcuD

.subckt Unnamed_aa715e86 w_n1078_n1609# a_n86_n1181# a_n142_n1389# a_n292_n1181# VSUBS
X0 w_n1078_n1609# w_n1078_n1609# w_n1078_n1609# w_n1078_n1609# pfet_03v3 ad=7.3p pd=21.46u as=29.2p ps=85.84u w=10u l=0.28u
X1 a_n292_n1181# a_n142_n1389# a_n86_n1181# w_n1078_n1609# pfet_03v3 ad=7.5p pd=21.5u as=4.3p ps=10.86u w=10u l=0.28u
X2 a_n86_n1181# a_n142_n1389# a_n292_n1181# w_n1078_n1609# pfet_03v3 ad=4.3p pd=10.86u as=7.5p ps=21.5u w=10u l=0.28u
X3 w_n1078_n1609# w_n1078_n1609# w_n1078_n1609# w_n1078_n1609# pfet_03v3 ad=7.3p pd=21.46u as=0 ps=0 w=10u l=0.28u
C0 a_n142_n1389# a_n86_n1181# 0.29284f
C1 a_n292_n1181# w_n1078_n1609# 1.92553f
C2 a_n292_n1181# a_n86_n1181# 3.10568f
C3 a_n142_n1389# a_n292_n1181# 0.22425f
C4 w_n1078_n1609# a_n86_n1181# 0.53563f
C5 a_n142_n1389# w_n1078_n1609# 0.70401f
C6 a_n86_n1181# VSUBS 0.02943f
C7 a_n292_n1181# VSUBS 0.33447f
C8 a_n142_n1389# VSUBS 0.10135f
C9 w_n1078_n1609# VSUBS 22.767f
.ends

.subckt Unnamed_3c60cbf2 a_n370_n2390# a_n520_n2180# w_n1806_n3110# a_n314_n2180#
+ VSUBS
X0 w_n1806_n3110# w_n1806_n3110# w_n1806_n3110# w_n1806_n3110# nfet_03v3 ad=14.6p pd=41.46u as=58.4p ps=0.16584m w=20u l=0.28u
X1 w_n1806_n3110# w_n1806_n3110# w_n1806_n3110# w_n1806_n3110# nfet_03v3 ad=14.6p pd=41.46u as=0 ps=0 w=20u l=0.28u
X2 a_n520_n2180# a_n370_n2390# a_n314_n2180# w_n1806_n3110# nfet_03v3 ad=15p pd=41.5u as=8.6p ps=20.86u w=20u l=0.28u
X3 a_n314_n2180# a_n370_n2390# a_n520_n2180# w_n1806_n3110# nfet_03v3 ad=8.6p pd=20.86u as=15p ps=41.5u w=20u l=0.28u
X4 a_n520_n2180# a_n370_n2390# a_n314_n2180# w_n1806_n3110# nfet_03v3 ad=8.6p pd=20.86u as=8.6p ps=20.86u w=20u l=0.28u
X5 a_n314_n2180# a_n370_n2390# a_n520_n2180# w_n1806_n3110# nfet_03v3 ad=8.6p pd=20.86u as=8.6p ps=20.86u w=20u l=0.28u
C0 w_n1806_n3110# a_n520_n2180# 2.45671f
C1 a_n370_n2390# a_n314_n2180# 0.98475f
C2 a_n370_n2390# a_n520_n2180# 0.92695f
C3 w_n1806_n3110# a_n370_n2390# 1.5486f
C4 a_n314_n2180# a_n520_n2180# 11.3334f
C5 w_n1806_n3110# a_n314_n2180# 0.54015f
C6 a_n314_n2180# VSUBS 0.42154f
C7 a_n520_n2180# VSUBS 1.76105f
C8 a_n370_n2390# VSUBS 0.25367f
C9 w_n1806_n3110# VSUBS 7.40085f
.ends

.subckt Unnamed_36f005e6 a_n370_n2390# a_n520_n2180# w_n1806_n3110# a_n314_n2180#
+ VSUBS
X0 w_n1806_n3110# w_n1806_n3110# w_n1806_n3110# w_n1806_n3110# nfet_03v3 ad=14.6p pd=41.46u as=58.4p ps=0.16584m w=20u l=0.28u
X1 w_n1806_n3110# w_n1806_n3110# w_n1806_n3110# w_n1806_n3110# nfet_03v3 ad=14.6p pd=41.46u as=0 ps=0 w=20u l=0.28u
X2 a_n520_n2180# a_n370_n2390# a_n314_n2180# w_n1806_n3110# nfet_03v3 ad=15p pd=41.5u as=8.6p ps=20.86u w=20u l=0.28u
X3 a_n314_n2180# a_n370_n2390# a_n520_n2180# w_n1806_n3110# nfet_03v3 ad=8.6p pd=20.86u as=15p ps=41.5u w=20u l=0.28u
X4 a_n520_n2180# a_n370_n2390# a_n314_n2180# w_n1806_n3110# nfet_03v3 ad=8.6p pd=20.86u as=8.6p ps=20.86u w=20u l=0.28u
X5 a_n314_n2180# a_n370_n2390# a_n520_n2180# w_n1806_n3110# nfet_03v3 ad=8.6p pd=20.86u as=8.6p ps=20.86u w=20u l=0.28u
C0 w_n1806_n3110# a_n520_n2180# 2.45671f
C1 a_n370_n2390# a_n314_n2180# 0.98475f
C2 a_n370_n2390# a_n520_n2180# 0.92695f
C3 w_n1806_n3110# a_n370_n2390# 1.5486f
C4 a_n314_n2180# a_n520_n2180# 11.3334f
C5 w_n1806_n3110# a_n314_n2180# 0.54015f
C6 a_n314_n2180# VSUBS 0.42154f
C7 a_n520_n2180# VSUBS 1.76105f
C8 a_n370_n2390# VSUBS 0.25367f
C9 w_n1806_n3110# VSUBS 7.40085f
.ends

.subckt lna_block_62479d0d w_n1806_3170# VSUBS
XUnnamed_aa715e86_0 w_n1806_3170# w_n1806_3170# w_n1806_3170# w_n1806_3170# VSUBS
+ Unnamed_aa715e86
XUnnamed_3c60cbf2_0 Unnamed_3c60cbf2_0/a_n370_n2390# Unnamed_3c60cbf2_0/a_n520_n2180#
+ w_n1806_3170# w_n1806_3170# VSUBS Unnamed_3c60cbf2
XUnnamed_36f005e6_0 w_n1806_3170# w_n1806_3170# w_n1806_3170# w_n1806_3170# VSUBS
+ Unnamed_36f005e6
C0 w_n1806_3170# Unnamed_3c60cbf2_0/a_n370_n2390# 0.07625f
C1 w_n1806_3170# Unnamed_3c60cbf2_0/a_n520_n2180# 0.98588f
C2 Unnamed_3c60cbf2_0/a_n520_n2180# Unnamed_3c60cbf2_0/a_n370_n2390# -0.00122f
C3 Unnamed_3c60cbf2_0/a_n520_n2180# VSUBS 1.76105f
C4 Unnamed_3c60cbf2_0/a_n370_n2390# VSUBS 0.25367f
C5 w_n1806_3170# VSUBS 43.51971f
.ends

.subckt Unnamed_6ab50a26 w_n1578_n1410# a_n142_n689# VSUBS
X0 a_n86_n481# a_n142_n689# a_n292_n481# w_n1578_n1410# nfet_03v3 ad=1.72p pd=4.86u as=3p ps=9.5u w=4u l=0.28u
X1 w_n1578_n1410# w_n1578_n1410# w_n1578_n1410# w_n1578_n1410# nfet_03v3 ad=2.92p pd=9.46u as=11.68p ps=37.84u w=4u l=0.28u
X2 w_n1578_n1410# w_n1578_n1410# w_n1578_n1410# w_n1578_n1410# nfet_03v3 ad=2.92p pd=9.46u as=0 ps=0 w=4u l=0.28u
X3 a_n292_n481# a_n142_n689# a_n86_n481# w_n1578_n1410# nfet_03v3 ad=3p pd=9.5u as=1.72p ps=4.86u w=4u l=0.28u
C0 a_n86_n481# a_n142_n689# 0.16869f
C1 a_n86_n481# w_n1578_n1410# 0.30404f
C2 a_n292_n481# a_n86_n481# 1.48546f
C3 a_n142_n689# w_n1578_n1410# 0.66703f
C4 a_n292_n481# a_n142_n689# 0.10807f
C5 a_n292_n481# w_n1578_n1410# 0.60578f
C6 a_n86_n481# VSUBS 0.16188f
C7 a_n292_n481# VSUBS 0.47364f
C8 a_n142_n689# VSUBS 0.13155f
C9 w_n1578_n1410# VSUBS 3.89724f
.ends

.subckt Unnamed_23824e57 a_n86_n481# w_n1578_n1410# a_n142_n689# VSUBS
X0 a_n86_n481# a_n142_n689# a_n292_n481# w_n1578_n1410# nfet_03v3 ad=1.72p pd=4.86u as=3p ps=9.5u w=4u l=0.28u
X1 w_n1578_n1410# w_n1578_n1410# w_n1578_n1410# w_n1578_n1410# nfet_03v3 ad=2.92p pd=9.46u as=11.68p ps=37.84u w=4u l=0.28u
X2 w_n1578_n1410# w_n1578_n1410# w_n1578_n1410# w_n1578_n1410# nfet_03v3 ad=2.92p pd=9.46u as=0 ps=0 w=4u l=0.28u
X3 a_n292_n481# a_n142_n689# a_n86_n481# w_n1578_n1410# nfet_03v3 ad=3p pd=9.5u as=1.72p ps=4.86u w=4u l=0.28u
C0 a_n86_n481# a_n142_n689# 0.16869f
C1 a_n86_n481# w_n1578_n1410# 0.30404f
C2 a_n292_n481# a_n86_n481# 1.48546f
C3 a_n142_n689# w_n1578_n1410# 0.66703f
C4 a_n292_n481# a_n142_n689# 0.10807f
C5 a_n292_n481# w_n1578_n1410# 0.60578f
C6 a_n86_n481# VSUBS 0.16188f
C7 a_n292_n481# VSUBS 0.47364f
C8 a_n142_n689# VSUBS 0.13155f
C9 w_n1578_n1410# VSUBS 3.89724f
.ends

.subckt rx_frontend_62479d0d w_3076_60# w_n656_n7889# w_3076_n2880# VSUBS
Xlna_block_62479d0d_0 w_n656_n7889# VSUBS lna_block_62479d0d
XUnnamed_6ab50a26_0 w_3076_60# Unnamed_6ab50a26_0/a_n142_n689# VSUBS Unnamed_6ab50a26
XUnnamed_23824e57_0 Unnamed_23824e57_0/a_n86_n481# w_3076_n2880# Unnamed_23824e57_0/a_n142_n689#
+ VSUBS Unnamed_23824e57
C0 Unnamed_23824e57_0/a_n142_n689# w_n656_n7889# 0
C1 w_3076_60# w_n656_n7889# 0.06036f
C2 w_3076_n2880# w_n656_n7889# 0.025f
C3 Unnamed_23824e57_0/a_n86_n481# Unnamed_6ab50a26_0/a_n142_n689# 0
C4 w_3076_n2880# Unnamed_6ab50a26_0/a_n142_n689# 0.00247f
C5 Unnamed_23824e57_0/a_n142_n689# w_3076_60# 0
C6 Unnamed_6ab50a26_0/a_n142_n689# w_n656_n7889# 0
C7 w_3076_n2880# w_3076_60# 0.13841f
C8 Unnamed_23824e57_0/a_n86_n481# VSUBS 0.16188f
C9 Unnamed_23824e57_0/a_n292_n481# VSUBS 0.47364f $ **FLOATING
C10 Unnamed_23824e57_0/a_n142_n689# VSUBS 0.13155f
C11 w_3076_n2880# VSUBS 1.86494f
C12 Unnamed_6ab50a26_0/a_n86_n481# VSUBS 0.16188f $ **FLOATING
C13 Unnamed_6ab50a26_0/a_n292_n481# VSUBS 0.47364f $ **FLOATING
C14 Unnamed_6ab50a26_0/a_n142_n689# VSUBS 0.13155f
C15 w_3076_60# VSUBS 1.62101f
C16 lna_block_62479d0d_0/Unnamed_3c60cbf2_0/a_n520_n2180# VSUBS 1.76105f
C17 lna_block_62479d0d_0/Unnamed_3c60cbf2_0/a_n370_n2390# VSUBS 0.25367f
C18 w_n656_n7889# VSUBS 39.71084f
.ends

.subckt rx_frontend
Xrx_frontend_62479d0d_0 w_3076_60# w_n656_n7889# w_3076_n2880# VSUBS rx_frontend_62479d0d
X0 w_n656_n7889.t2 w_n656_n7889.t0 w_n656_n7889.t2 w_n656_n7889.t1 nfet_03v3 ad=8.6p pd=20.86u as=8.6p ps=20.86u w=0 l=0
X1 w_n656_n7889.t11 w_n656_n7889.t9 w_n656_n7889.t11 w_n656_n7889.t10 nfet_03v3 ad=15p pd=41.5u as=8.6p ps=20.86u w=0 l=0
X2 w_n656_n7889.t27 w_n656_n7889.t25 w_n656_n7889.t27 w_n656_n7889.t26 pfet_03v3 ad=4.3p pd=10.86u as=7.5p ps=21.5u w=0 l=0
X3 w_n656_n7889.t17 w_n656_n7889.t15 w_n656_n7889.t17 w_n656_n7889.t16 nfet_03v3 ad=14.6p pd=41.46u as=0 ps=0 w=0 l=0
X4 w_n656_n7889.t8 w_n656_n7889.t6 w_n656_n7889.t8 w_n656_n7889.t7 nfet_03v3 ad=8.6p pd=20.86u as=15p ps=41.5u w=0 l=0
X5 w_n656_n7889.t33 w_n656_n7889.t31 w_n656_n7889.t33 w_n656_n7889.t32 pfet_03v3 ad=7.3p pd=21.46u as=0 ps=0 w=0 l=0
X6 w_n656_n7889.t30 w_n656_n7889.t28 w_n656_n7889.t30 w_n656_n7889.t29 pfet_03v3 ad=7.5p pd=21.5u as=4.3p ps=10.86u w=0 l=0
X7 w_n656_n7889.t21 w_n656_n7889.t20 w_n656_n7889.t21 w_n656_n7889.t16 nfet_03v3 ad=14.6p pd=41.46u as=0 ps=0 w=0 l=0
X8 w_n656_n7889.t19 w_n656_n7889.t18 w_n656_n7889.t19 w_n656_n7889.t13 nfet_03v3 ad=14.6p pd=41.46u as=0 ps=0 w=0 l=0
X9 w_n656_n7889.t24 w_n656_n7889.t22 w_n656_n7889.t24 w_n656_n7889.t23 pfet_03v3 ad=7.3p pd=21.46u as=0 ps=0 w=0 l=0
X10 w_n656_n7889.t14 w_n656_n7889.t12 w_n656_n7889.t14 w_n656_n7889.t13 nfet_03v3 ad=14.6p pd=41.46u as=0 ps=0 w=0 l=0
X11 w_n656_n7889.t5 w_n656_n7889.t3 w_n656_n7889.t5 w_n656_n7889.t4 nfet_03v3 ad=8.6p pd=20.86u as=8.6p ps=20.86u w=0 l=0
R0 w_n656_n7889.n329 w_n656_n7889.n308 337.421
R1 w_n656_n7889.n346 w_n656_n7889.t9 282.5
R2 w_n656_n7889.n350 w_n656_n7889.t6 281.348
R3 w_n656_n7889.n90 w_n656_n7889.t18 278.678
R4 w_n656_n7889.n320 w_n656_n7889.t20 278.678
R5 w_n656_n7889.n147 w_n656_n7889.t15 278.678
R6 w_n656_n7889.n348 w_n656_n7889.t0 275.055
R7 w_n656_n7889.n352 w_n656_n7889.t3 275.055
R8 w_n656_n7889.n588 w_n656_n7889.t12 271.39
R9 w_n656_n7889.n604 w_n656_n7889.n87 266
R10 w_n656_n7889.n604 w_n656_n7889.n88 266
R11 w_n656_n7889.n310 w_n656_n7889.n309 266
R12 w_n656_n7889.n327 w_n656_n7889.n309 266
R13 w_n656_n7889.n330 w_n656_n7889.n141 266
R14 w_n656_n7889.n330 w_n656_n7889.n144 266
R15 w_n656_n7889.n676 w_n656_n7889.n675 254.506
R16 w_n656_n7889.n629 w_n656_n7889.n622 152.863
R17 w_n656_n7889.n674 w_n656_n7889.n1 152.863
R18 w_n656_n7889.n674 w_n656_n7889.n2 152.863
R19 w_n656_n7889.n66 w_n656_n7889.t28 152.758
R20 w_n656_n7889.n66 w_n656_n7889.t25 152.758
R21 w_n656_n7889.n4 w_n656_n7889.t31 148.321
R22 w_n656_n7889.n625 w_n656_n7889.t22 148.321
R23 w_n656_n7889.n85 w_n656_n7889.n84 135.589
R24 w_n656_n7889.n607 w_n656_n7889.n81 135.139
R25 w_n656_n7889.n307 w_n656_n7889.n153 101.889
R26 w_n656_n7889.n307 w_n656_n7889.n154 101.889
R27 w_n656_n7889.n221 w_n656_n7889.n205 101.889
R28 w_n656_n7889.n247 w_n656_n7889.n221 101.889
R29 w_n656_n7889.n285 w_n656_n7889.n152 101.889
R30 w_n656_n7889.n279 w_n656_n7889.n152 101.889
R31 w_n656_n7889.n219 w_n656_n7889.n203 101.889
R32 w_n656_n7889.n249 w_n656_n7889.n203 101.889
R33 w_n656_n7889.n350 w_n656_n7889.n349 85.9059
R34 w_n656_n7889.n675 w_n656_n7889.n0 82.6605
R35 w_n656_n7889.n588 w_n656_n7889.n587 77.3023
R36 w_n656_n7889.n158 w_n656_n7889.n156 70.1068
R37 w_n656_n7889.n242 w_n656_n7889.n240 70.1068
R38 w_n656_n7889.n182 w_n656_n7889.n180 70.1068
R39 w_n656_n7889.n209 w_n656_n7889.n207 70.1068
R40 w_n656_n7889.n248 w_n656_n7889.n204 68.8301
R41 w_n656_n7889.n308 w_n656_n7889.n151 68.8301
R42 w_n656_n7889.n329 w_n656_n7889.n328 65.725
R43 w_n656_n7889.n86 w_n656_n7889.n85 58.9973
R44 w_n656_n7889.n629 w_n656_n7889.n628 52.3429
R45 w_n656_n7889.n650 w_n656_n7889.n621 49.7208
R46 w_n656_n7889.n644 w_n656_n7889.n621 49.7208
R47 w_n656_n7889.n643 w_n656_n7889.n642 49.7208
R48 w_n656_n7889.n658 w_n656_n7889.n8 49.7208
R49 w_n656_n7889.n667 w_n656_n7889.n8 49.7208
R50 w_n656_n7889.n605 w_n656_n7889.n83 46.0594
R51 w_n656_n7889.n261 w_n656_n7889.n196 41.4018
R52 w_n656_n7889.n261 w_n656_n7889.n188 41.4018
R53 w_n656_n7889.n269 w_n656_n7889.n188 41.4018
R54 w_n656_n7889.n269 w_n656_n7889.n171 41.4018
R55 w_n656_n7889.n291 w_n656_n7889.n171 41.4018
R56 w_n656_n7889.n291 w_n656_n7889.n162 41.4018
R57 w_n656_n7889.n300 w_n656_n7889.n162 41.4018
R58 w_n656_n7889.n336 w_n656_n7889.n124 41.4018
R59 w_n656_n7889.n539 w_n656_n7889.n124 41.4018
R60 w_n656_n7889.n545 w_n656_n7889.n119 41.4018
R61 w_n656_n7889.n573 w_n656_n7889.n101 41.4018
R62 w_n656_n7889.n644 w_n656_n7889.t29 39.1553
R63 w_n656_n7889.n658 w_n656_n7889.t26 39.1553
R64 w_n656_n7889.n573 w_n656_n7889.n94 35.9679
R65 w_n656_n7889.n539 w_n656_n7889.t10 35.7091
R66 w_n656_n7889.n513 w_n656_n7889.t7 33.3803
R67 w_n656_n7889.n559 w_n656_n7889.n107 32.0865
R68 w_n656_n7889.n530 w_n656_n7889.t1 29.4989
R69 w_n656_n7889.n530 w_n656_n7889.t4 29.4989
R70 w_n656_n7889.n627 w_n656_n7889.t23 25.4822
R71 w_n656_n7889.t32 w_n656_n7889.n0 25.4822
R72 w_n656_n7889.n328 w_n656_n7889.t16 24.3237
R73 w_n656_n7889.t13 w_n656_n7889.n595 24.3237
R74 w_n656_n7889.n650 w_n656_n7889.t23 24.2392
R75 w_n656_n7889.n667 w_n656_n7889.t32 24.2392
R76 w_n656_n7889.n248 w_n656_n7889.n220 21.2187
R77 w_n656_n7889.n164 w_n656_n7889.n151 21.2187
R78 w_n656_n7889.n220 w_n656_n7889.n196 20.1836
R79 w_n656_n7889.n300 w_n656_n7889.n164 20.1836
R80 w_n656_n7889.n595 w_n656_n7889.n83 19.6661
R81 w_n656_n7889.n336 w_n656_n7889.t16 17.0785
R82 w_n656_n7889.n223 w_n656_n7889.n205 15.5561
R83 w_n656_n7889.n223 w_n656_n7889.n197 15.5561
R84 w_n656_n7889.n234 w_n656_n7889.n197 15.5561
R85 w_n656_n7889.n234 w_n656_n7889.n189 15.5561
R86 w_n656_n7889.n231 w_n656_n7889.n189 15.5561
R87 w_n656_n7889.n231 w_n656_n7889.n172 15.5561
R88 w_n656_n7889.n172 w_n656_n7889.n161 15.5561
R89 w_n656_n7889.n301 w_n656_n7889.n161 15.5561
R90 w_n656_n7889.n301 w_n656_n7889.n154 15.5561
R91 w_n656_n7889.n247 w_n656_n7889.n195 15.5561
R92 w_n656_n7889.n262 w_n656_n7889.n195 15.5561
R93 w_n656_n7889.n262 w_n656_n7889.n191 15.5561
R94 w_n656_n7889.n268 w_n656_n7889.n191 15.5561
R95 w_n656_n7889.n268 w_n656_n7889.n170 15.5561
R96 w_n656_n7889.n292 w_n656_n7889.n170 15.5561
R97 w_n656_n7889.n292 w_n656_n7889.n166 15.5561
R98 w_n656_n7889.n299 w_n656_n7889.n166 15.5561
R99 w_n656_n7889.n299 w_n656_n7889.n153 15.5561
R100 w_n656_n7889.n219 w_n656_n7889.n206 15.5561
R101 w_n656_n7889.n206 w_n656_n7889.n198 15.5561
R102 w_n656_n7889.n198 w_n656_n7889.n187 15.5561
R103 w_n656_n7889.n270 w_n656_n7889.n187 15.5561
R104 w_n656_n7889.n271 w_n656_n7889.n270 15.5561
R105 w_n656_n7889.n271 w_n656_n7889.n173 15.5561
R106 w_n656_n7889.n276 w_n656_n7889.n173 15.5561
R107 w_n656_n7889.n276 w_n656_n7889.n163 15.5561
R108 w_n656_n7889.n279 w_n656_n7889.n163 15.5561
R109 w_n656_n7889.n249 w_n656_n7889.n199 15.5561
R110 w_n656_n7889.n260 w_n656_n7889.n199 15.5561
R111 w_n656_n7889.n260 w_n656_n7889.n200 15.5561
R112 w_n656_n7889.n200 w_n656_n7889.n190 15.5561
R113 w_n656_n7889.n190 w_n656_n7889.n174 15.5561
R114 w_n656_n7889.n290 w_n656_n7889.n174 15.5561
R115 w_n656_n7889.n290 w_n656_n7889.n175 15.5561
R116 w_n656_n7889.n175 w_n656_n7889.n165 15.5561
R117 w_n656_n7889.n285 w_n656_n7889.n165 15.5561
R118 w_n656_n7889.n310 w_n656_n7889.n142 15.5561
R119 w_n656_n7889.n315 w_n656_n7889.n142 15.5561
R120 w_n656_n7889.n315 w_n656_n7889.n126 15.5561
R121 w_n656_n7889.n126 w_n656_n7889.n118 15.5561
R122 w_n656_n7889.n546 w_n656_n7889.n118 15.5561
R123 w_n656_n7889.n546 w_n656_n7889.n114 15.5561
R124 w_n656_n7889.n558 w_n656_n7889.n114 15.5561
R125 w_n656_n7889.n558 w_n656_n7889.n109 15.5561
R126 w_n656_n7889.n554 w_n656_n7889.n109 15.5561
R127 w_n656_n7889.n554 w_n656_n7889.n93 15.5561
R128 w_n656_n7889.n598 w_n656_n7889.n93 15.5561
R129 w_n656_n7889.n598 w_n656_n7889.n88 15.5561
R130 w_n656_n7889.n327 w_n656_n7889.n143 15.5561
R131 w_n656_n7889.n143 w_n656_n7889.n127 15.5561
R132 w_n656_n7889.n538 w_n656_n7889.n127 15.5561
R133 w_n656_n7889.n538 w_n656_n7889.n128 15.5561
R134 w_n656_n7889.n128 w_n656_n7889.n121 15.5561
R135 w_n656_n7889.n531 w_n656_n7889.n121 15.5561
R136 w_n656_n7889.n531 w_n656_n7889.n106 15.5561
R137 w_n656_n7889.n563 w_n656_n7889.n106 15.5561
R138 w_n656_n7889.n563 w_n656_n7889.n102 15.5561
R139 w_n656_n7889.n572 w_n656_n7889.n102 15.5561
R140 w_n656_n7889.n572 w_n656_n7889.n95 15.5561
R141 w_n656_n7889.n95 w_n656_n7889.n87 15.5561
R142 w_n656_n7889.n337 w_n656_n7889.n141 15.5561
R143 w_n656_n7889.n338 w_n656_n7889.n337 15.5561
R144 w_n656_n7889.n338 w_n656_n7889.n125 15.5561
R145 w_n656_n7889.n339 w_n656_n7889.n125 15.5561
R146 w_n656_n7889.n339 w_n656_n7889.n120 15.5561
R147 w_n656_n7889.n529 w_n656_n7889.n120 15.5561
R148 w_n656_n7889.n529 w_n656_n7889.n113 15.5561
R149 w_n656_n7889.n335 w_n656_n7889.n144 15.5561
R150 w_n656_n7889.n335 w_n656_n7889.n122 15.5561
R151 w_n656_n7889.n540 w_n656_n7889.n122 15.5561
R152 w_n656_n7889.n541 w_n656_n7889.n540 15.5561
R153 w_n656_n7889.n544 w_n656_n7889.n541 15.5561
R154 w_n656_n7889.n544 w_n656_n7889.n110 15.5561
R155 w_n656_n7889.n560 w_n656_n7889.n110 15.5561
R156 w_n656_n7889.n561 w_n656_n7889.n560 15.5561
R157 w_n656_n7889.n561 w_n656_n7889.n76 15.5561
R158 w_n656_n7889.n77 w_n656_n7889.n76 15.5561
R159 w_n656_n7889.n78 w_n656_n7889.n77 15.5561
R160 w_n656_n7889.n81 w_n656_n7889.n78 15.5561
R161 w_n656_n7889.n596 w_n656_n7889.t13 15.0085
R162 w_n656_n7889.n649 w_n656_n7889.n622 14.0005
R163 w_n656_n7889.n649 w_n656_n7889.n623 14.0005
R164 w_n656_n7889.n645 w_n656_n7889.n623 14.0005
R165 w_n656_n7889.n645 w_n656_n7889.n637 14.0005
R166 w_n656_n7889.n637 w_n656_n7889.n13 14.0005
R167 w_n656_n7889.n659 w_n656_n7889.n13 14.0005
R168 w_n656_n7889.n659 w_n656_n7889.n9 14.0005
R169 w_n656_n7889.n666 w_n656_n7889.n9 14.0005
R170 w_n656_n7889.n666 w_n656_n7889.n1 14.0005
R171 w_n656_n7889.n651 w_n656_n7889.n619 14.0005
R172 w_n656_n7889.n651 w_n656_n7889.n620 14.0005
R173 w_n656_n7889.n638 w_n656_n7889.n620 14.0005
R174 w_n656_n7889.n641 w_n656_n7889.n638 14.0005
R175 w_n656_n7889.n641 w_n656_n7889.n14 14.0005
R176 w_n656_n7889.n657 w_n656_n7889.n14 14.0005
R177 w_n656_n7889.n657 w_n656_n7889.n7 14.0005
R178 w_n656_n7889.n668 w_n656_n7889.n7 14.0005
R179 w_n656_n7889.n668 w_n656_n7889.n2 14.0005
R180 w_n656_n7889.n514 w_n656_n7889.n512 13.9033
R181 w_n656_n7889.n575 w_n656_n7889.n574 13.5144
R182 w_n656_n7889.n605 w_n656_n7889.n86 12.9384
R183 w_n656_n7889.n506 w_n656_n7889.n346 12.7255
R184 w_n656_n7889.n67 w_n656_n7889.n66 12.5005
R185 w_n656_n7889.n355 w_n656_n7889.n354 12.5005
R186 w_n656_n7889.n353 w_n656_n7889.n347 12.5005
R187 w_n656_n7889.n545 w_n656_n7889.t1 11.9034
R188 w_n656_n7889.n559 w_n656_n7889.t4 11.9034
R189 w_n656_n7889.n354 w_n656_n7889.n353 11.6805
R190 w_n656_n7889.t29 w_n656_n7889.n643 10.5661
R191 w_n656_n7889.n642 w_n656_n7889.t26 10.5661
R192 w_n656_n7889.n592 w_n656_n7889.n80 10.5344
R193 w_n656_n7889.n595 w_n656_n7889.n594 10.4005
R194 w_n656_n7889.n606 w_n656_n7889.n82 10.2954
R195 w_n656_n7889.n562 w_n656_n7889.n107 9.31579
R196 w_n656_n7889.n348 w_n656_n7889.n346 9.1985
R197 w_n656_n7889.n352 w_n656_n7889.n351 8.9795
R198 w_n656_n7889.n589 w_n656_n7889.n588 8.0005
R199 w_n656_n7889.n351 w_n656_n7889.n137 8.0005
R200 w_n656_n7889.n603 w_n656_n7889.n89 7.18485
R201 w_n656_n7889.n323 w_n656_n7889.n322 7.18485
R202 w_n656_n7889.n332 w_n656_n7889.n331 7.18485
R203 w_n656_n7889.n670 w_n656_n7889.n2 6.3005
R204 w_n656_n7889.n2 w_n656_n7889.n0 6.3005
R205 w_n656_n7889.n669 w_n656_n7889.n668 6.3005
R206 w_n656_n7889.n668 w_n656_n7889.n667 6.3005
R207 w_n656_n7889.n7 w_n656_n7889.n6 6.3005
R208 w_n656_n7889.n8 w_n656_n7889.n7 6.3005
R209 w_n656_n7889.n657 w_n656_n7889.n656 6.3005
R210 w_n656_n7889.n658 w_n656_n7889.n657 6.3005
R211 w_n656_n7889.n15 w_n656_n7889.n14 6.3005
R212 w_n656_n7889.n642 w_n656_n7889.n14 6.3005
R213 w_n656_n7889.n641 w_n656_n7889.n640 6.3005
R214 w_n656_n7889.n643 w_n656_n7889.n641 6.3005
R215 w_n656_n7889.n639 w_n656_n7889.n638 6.3005
R216 w_n656_n7889.n644 w_n656_n7889.n638 6.3005
R217 w_n656_n7889.n620 w_n656_n7889.n618 6.3005
R218 w_n656_n7889.n621 w_n656_n7889.n620 6.3005
R219 w_n656_n7889.n652 w_n656_n7889.n651 6.3005
R220 w_n656_n7889.n651 w_n656_n7889.n650 6.3005
R221 w_n656_n7889.n619 w_n656_n7889.n617 6.3005
R222 w_n656_n7889.n624 w_n656_n7889.n622 6.3005
R223 w_n656_n7889.n627 w_n656_n7889.n622 6.3005
R224 w_n656_n7889.n649 w_n656_n7889.n648 6.3005
R225 w_n656_n7889.n650 w_n656_n7889.n649 6.3005
R226 w_n656_n7889.n647 w_n656_n7889.n623 6.3005
R227 w_n656_n7889.n623 w_n656_n7889.n621 6.3005
R228 w_n656_n7889.n646 w_n656_n7889.n645 6.3005
R229 w_n656_n7889.n645 w_n656_n7889.n644 6.3005
R230 w_n656_n7889.n637 w_n656_n7889.n636 6.3005
R231 w_n656_n7889.n643 w_n656_n7889.n637 6.3005
R232 w_n656_n7889.n13 w_n656_n7889.n12 6.3005
R233 w_n656_n7889.n642 w_n656_n7889.n13 6.3005
R234 w_n656_n7889.n660 w_n656_n7889.n659 6.3005
R235 w_n656_n7889.n659 w_n656_n7889.n658 6.3005
R236 w_n656_n7889.n10 w_n656_n7889.n9 6.3005
R237 w_n656_n7889.n9 w_n656_n7889.n8 6.3005
R238 w_n656_n7889.n666 w_n656_n7889.n665 6.3005
R239 w_n656_n7889.n667 w_n656_n7889.n666 6.3005
R240 w_n656_n7889.n664 w_n656_n7889.n1 6.3005
R241 w_n656_n7889.n1 w_n656_n7889.n0 6.3005
R242 w_n656_n7889.n631 w_n656_n7889.n630 6.21641
R243 w_n656_n7889.n673 w_n656_n7889.n3 6.21641
R244 w_n656_n7889.n609 w_n656_n7889.n608 5.86811
R245 w_n656_n7889.t10 w_n656_n7889.n119 5.69318
R246 w_n656_n7889.n306 w_n656_n7889.n155 5.5326
R247 w_n656_n7889.n245 w_n656_n7889.n244 5.5326
R248 w_n656_n7889.n284 w_n656_n7889.n283 5.5326
R249 w_n656_n7889.n251 w_n656_n7889.n202 5.5326
R250 w_n656_n7889.n597 w_n656_n7889.n94 5.43442
R251 w_n656_n7889.n569 w_n656_n7889.n87 5.2005
R252 w_n656_n7889.n595 w_n656_n7889.n87 5.2005
R253 w_n656_n7889.n570 w_n656_n7889.n95 5.2005
R254 w_n656_n7889.n597 w_n656_n7889.n95 5.2005
R255 w_n656_n7889.n572 w_n656_n7889.n571 5.2005
R256 w_n656_n7889.n573 w_n656_n7889.n572 5.2005
R257 w_n656_n7889.n103 w_n656_n7889.n102 5.2005
R258 w_n656_n7889.n102 w_n656_n7889.n101 5.2005
R259 w_n656_n7889.n564 w_n656_n7889.n563 5.2005
R260 w_n656_n7889.n563 w_n656_n7889.n562 5.2005
R261 w_n656_n7889.n106 w_n656_n7889.n105 5.2005
R262 w_n656_n7889.n559 w_n656_n7889.n106 5.2005
R263 w_n656_n7889.n532 w_n656_n7889.n531 5.2005
R264 w_n656_n7889.n531 w_n656_n7889.n530 5.2005
R265 w_n656_n7889.n533 w_n656_n7889.n121 5.2005
R266 w_n656_n7889.n545 w_n656_n7889.n121 5.2005
R267 w_n656_n7889.n130 w_n656_n7889.n128 5.2005
R268 w_n656_n7889.n128 w_n656_n7889.n119 5.2005
R269 w_n656_n7889.n538 w_n656_n7889.n537 5.2005
R270 w_n656_n7889.n539 w_n656_n7889.n538 5.2005
R271 w_n656_n7889.n129 w_n656_n7889.n127 5.2005
R272 w_n656_n7889.n127 w_n656_n7889.n124 5.2005
R273 w_n656_n7889.n325 w_n656_n7889.n143 5.2005
R274 w_n656_n7889.n336 w_n656_n7889.n143 5.2005
R275 w_n656_n7889.n327 w_n656_n7889.n326 5.2005
R276 w_n656_n7889.n328 w_n656_n7889.n327 5.2005
R277 w_n656_n7889.n600 w_n656_n7889.n88 5.2005
R278 w_n656_n7889.n595 w_n656_n7889.n88 5.2005
R279 w_n656_n7889.n599 w_n656_n7889.n598 5.2005
R280 w_n656_n7889.n598 w_n656_n7889.n597 5.2005
R281 w_n656_n7889.n93 w_n656_n7889.n92 5.2005
R282 w_n656_n7889.n573 w_n656_n7889.n93 5.2005
R283 w_n656_n7889.n555 w_n656_n7889.n554 5.2005
R284 w_n656_n7889.n554 w_n656_n7889.n101 5.2005
R285 w_n656_n7889.n556 w_n656_n7889.n109 5.2005
R286 w_n656_n7889.n562 w_n656_n7889.n109 5.2005
R287 w_n656_n7889.n558 w_n656_n7889.n557 5.2005
R288 w_n656_n7889.n559 w_n656_n7889.n558 5.2005
R289 w_n656_n7889.n115 w_n656_n7889.n114 5.2005
R290 w_n656_n7889.n530 w_n656_n7889.n114 5.2005
R291 w_n656_n7889.n547 w_n656_n7889.n546 5.2005
R292 w_n656_n7889.n546 w_n656_n7889.n545 5.2005
R293 w_n656_n7889.n118 w_n656_n7889.n117 5.2005
R294 w_n656_n7889.n119 w_n656_n7889.n118 5.2005
R295 w_n656_n7889.n314 w_n656_n7889.n126 5.2005
R296 w_n656_n7889.n539 w_n656_n7889.n126 5.2005
R297 w_n656_n7889.n316 w_n656_n7889.n315 5.2005
R298 w_n656_n7889.n315 w_n656_n7889.n124 5.2005
R299 w_n656_n7889.n317 w_n656_n7889.n142 5.2005
R300 w_n656_n7889.n336 w_n656_n7889.n142 5.2005
R301 w_n656_n7889.n318 w_n656_n7889.n310 5.2005
R302 w_n656_n7889.n328 w_n656_n7889.n310 5.2005
R303 w_n656_n7889.n286 w_n656_n7889.n285 5.2005
R304 w_n656_n7889.n285 w_n656_n7889.n151 5.2005
R305 w_n656_n7889.n287 w_n656_n7889.n165 5.2005
R306 w_n656_n7889.n300 w_n656_n7889.n165 5.2005
R307 w_n656_n7889.n288 w_n656_n7889.n175 5.2005
R308 w_n656_n7889.n175 w_n656_n7889.n162 5.2005
R309 w_n656_n7889.n290 w_n656_n7889.n289 5.2005
R310 w_n656_n7889.n291 w_n656_n7889.n290 5.2005
R311 w_n656_n7889.n176 w_n656_n7889.n174 5.2005
R312 w_n656_n7889.n174 w_n656_n7889.n171 5.2005
R313 w_n656_n7889.n257 w_n656_n7889.n190 5.2005
R314 w_n656_n7889.n269 w_n656_n7889.n190 5.2005
R315 w_n656_n7889.n258 w_n656_n7889.n200 5.2005
R316 w_n656_n7889.n200 w_n656_n7889.n188 5.2005
R317 w_n656_n7889.n260 w_n656_n7889.n259 5.2005
R318 w_n656_n7889.n261 w_n656_n7889.n260 5.2005
R319 w_n656_n7889.n201 w_n656_n7889.n199 5.2005
R320 w_n656_n7889.n199 w_n656_n7889.n196 5.2005
R321 w_n656_n7889.n250 w_n656_n7889.n249 5.2005
R322 w_n656_n7889.n249 w_n656_n7889.n248 5.2005
R323 w_n656_n7889.n280 w_n656_n7889.n279 5.2005
R324 w_n656_n7889.n279 w_n656_n7889.n151 5.2005
R325 w_n656_n7889.n278 w_n656_n7889.n163 5.2005
R326 w_n656_n7889.n300 w_n656_n7889.n163 5.2005
R327 w_n656_n7889.n277 w_n656_n7889.n276 5.2005
R328 w_n656_n7889.n276 w_n656_n7889.n162 5.2005
R329 w_n656_n7889.n184 w_n656_n7889.n173 5.2005
R330 w_n656_n7889.n291 w_n656_n7889.n173 5.2005
R331 w_n656_n7889.n272 w_n656_n7889.n271 5.2005
R332 w_n656_n7889.n271 w_n656_n7889.n171 5.2005
R333 w_n656_n7889.n270 w_n656_n7889.n186 5.2005
R334 w_n656_n7889.n270 w_n656_n7889.n269 5.2005
R335 w_n656_n7889.n213 w_n656_n7889.n187 5.2005
R336 w_n656_n7889.n188 w_n656_n7889.n187 5.2005
R337 w_n656_n7889.n212 w_n656_n7889.n198 5.2005
R338 w_n656_n7889.n261 w_n656_n7889.n198 5.2005
R339 w_n656_n7889.n217 w_n656_n7889.n206 5.2005
R340 w_n656_n7889.n206 w_n656_n7889.n196 5.2005
R341 w_n656_n7889.n219 w_n656_n7889.n218 5.2005
R342 w_n656_n7889.n248 w_n656_n7889.n219 5.2005
R343 w_n656_n7889.n297 w_n656_n7889.n153 5.2005
R344 w_n656_n7889.n153 w_n656_n7889.n151 5.2005
R345 w_n656_n7889.n299 w_n656_n7889.n298 5.2005
R346 w_n656_n7889.n300 w_n656_n7889.n299 5.2005
R347 w_n656_n7889.n167 w_n656_n7889.n166 5.2005
R348 w_n656_n7889.n166 w_n656_n7889.n162 5.2005
R349 w_n656_n7889.n293 w_n656_n7889.n292 5.2005
R350 w_n656_n7889.n292 w_n656_n7889.n291 5.2005
R351 w_n656_n7889.n170 w_n656_n7889.n169 5.2005
R352 w_n656_n7889.n171 w_n656_n7889.n170 5.2005
R353 w_n656_n7889.n268 w_n656_n7889.n267 5.2005
R354 w_n656_n7889.n269 w_n656_n7889.n268 5.2005
R355 w_n656_n7889.n192 w_n656_n7889.n191 5.2005
R356 w_n656_n7889.n191 w_n656_n7889.n188 5.2005
R357 w_n656_n7889.n263 w_n656_n7889.n262 5.2005
R358 w_n656_n7889.n262 w_n656_n7889.n261 5.2005
R359 w_n656_n7889.n195 w_n656_n7889.n194 5.2005
R360 w_n656_n7889.n196 w_n656_n7889.n195 5.2005
R361 w_n656_n7889.n247 w_n656_n7889.n246 5.2005
R362 w_n656_n7889.n248 w_n656_n7889.n247 5.2005
R363 w_n656_n7889.n303 w_n656_n7889.n154 5.2005
R364 w_n656_n7889.n154 w_n656_n7889.n151 5.2005
R365 w_n656_n7889.n302 w_n656_n7889.n301 5.2005
R366 w_n656_n7889.n301 w_n656_n7889.n300 5.2005
R367 w_n656_n7889.n161 w_n656_n7889.n160 5.2005
R368 w_n656_n7889.n162 w_n656_n7889.n161 5.2005
R369 w_n656_n7889.n230 w_n656_n7889.n172 5.2005
R370 w_n656_n7889.n291 w_n656_n7889.n172 5.2005
R371 w_n656_n7889.n232 w_n656_n7889.n231 5.2005
R372 w_n656_n7889.n231 w_n656_n7889.n171 5.2005
R373 w_n656_n7889.n233 w_n656_n7889.n189 5.2005
R374 w_n656_n7889.n269 w_n656_n7889.n189 5.2005
R375 w_n656_n7889.n235 w_n656_n7889.n234 5.2005
R376 w_n656_n7889.n234 w_n656_n7889.n188 5.2005
R377 w_n656_n7889.n236 w_n656_n7889.n197 5.2005
R378 w_n656_n7889.n261 w_n656_n7889.n197 5.2005
R379 w_n656_n7889.n237 w_n656_n7889.n223 5.2005
R380 w_n656_n7889.n223 w_n656_n7889.n196 5.2005
R381 w_n656_n7889.n238 w_n656_n7889.n205 5.2005
R382 w_n656_n7889.n248 w_n656_n7889.n205 5.2005
R383 w_n656_n7889.n576 w_n656_n7889.n575 5.2005
R384 w_n656_n7889.n575 w_n656_n7889.n94 5.2005
R385 w_n656_n7889.n574 w_n656_n7889.n100 5.2005
R386 w_n656_n7889.n574 w_n656_n7889.n573 5.2005
R387 w_n656_n7889.n515 w_n656_n7889.n514 5.2005
R388 w_n656_n7889.n514 w_n656_n7889.n513 5.2005
R389 w_n656_n7889.n512 w_n656_n7889.n135 5.2005
R390 w_n656_n7889.n512 w_n656_n7889.n108 5.2005
R391 w_n656_n7889.n526 w_n656_n7889.n113 5.2005
R392 w_n656_n7889.n559 w_n656_n7889.n113 5.2005
R393 w_n656_n7889.n529 w_n656_n7889.n528 5.2005
R394 w_n656_n7889.n530 w_n656_n7889.n529 5.2005
R395 w_n656_n7889.n132 w_n656_n7889.n120 5.2005
R396 w_n656_n7889.n545 w_n656_n7889.n120 5.2005
R397 w_n656_n7889.n340 w_n656_n7889.n339 5.2005
R398 w_n656_n7889.n339 w_n656_n7889.n119 5.2005
R399 w_n656_n7889.n342 w_n656_n7889.n125 5.2005
R400 w_n656_n7889.n539 w_n656_n7889.n125 5.2005
R401 w_n656_n7889.n343 w_n656_n7889.n338 5.2005
R402 w_n656_n7889.n338 w_n656_n7889.n124 5.2005
R403 w_n656_n7889.n337 w_n656_n7889.n140 5.2005
R404 w_n656_n7889.n337 w_n656_n7889.n336 5.2005
R405 w_n656_n7889.n148 w_n656_n7889.n141 5.2005
R406 w_n656_n7889.n328 w_n656_n7889.n141 5.2005
R407 w_n656_n7889.n81 w_n656_n7889.n79 5.2005
R408 w_n656_n7889.n595 w_n656_n7889.n81 5.2005
R409 w_n656_n7889.n611 w_n656_n7889.n78 5.2005
R410 w_n656_n7889.n597 w_n656_n7889.n78 5.2005
R411 w_n656_n7889.n612 w_n656_n7889.n77 5.2005
R412 w_n656_n7889.n573 w_n656_n7889.n77 5.2005
R413 w_n656_n7889.n613 w_n656_n7889.n76 5.2005
R414 w_n656_n7889.n101 w_n656_n7889.n76 5.2005
R415 w_n656_n7889.n561 w_n656_n7889.n75 5.2005
R416 w_n656_n7889.n562 w_n656_n7889.n561 5.2005
R417 w_n656_n7889.n560 w_n656_n7889.n112 5.2005
R418 w_n656_n7889.n560 w_n656_n7889.n559 5.2005
R419 w_n656_n7889.n111 w_n656_n7889.n110 5.2005
R420 w_n656_n7889.n530 w_n656_n7889.n110 5.2005
R421 w_n656_n7889.n544 w_n656_n7889.n543 5.2005
R422 w_n656_n7889.n545 w_n656_n7889.n544 5.2005
R423 w_n656_n7889.n542 w_n656_n7889.n541 5.2005
R424 w_n656_n7889.n541 w_n656_n7889.n119 5.2005
R425 w_n656_n7889.n540 w_n656_n7889.n123 5.2005
R426 w_n656_n7889.n540 w_n656_n7889.n539 5.2005
R427 w_n656_n7889.n146 w_n656_n7889.n122 5.2005
R428 w_n656_n7889.n124 w_n656_n7889.n122 5.2005
R429 w_n656_n7889.n335 w_n656_n7889.n334 5.2005
R430 w_n656_n7889.n336 w_n656_n7889.n335 5.2005
R431 w_n656_n7889.n145 w_n656_n7889.n144 5.2005
R432 w_n656_n7889.n328 w_n656_n7889.n144 5.2005
R433 w_n656_n7889.n439 w_n656_n7889.n71 5.10898
R434 w_n656_n7889.n441 w_n656_n7889.n71 5.10898
R435 w_n656_n7889.n36 w_n656_n7889.n31 5.10026
R436 w_n656_n7889.n305 w_n656_n7889.n304 4.9251
R437 w_n656_n7889.n243 w_n656_n7889.n239 4.9251
R438 w_n656_n7889.n282 w_n656_n7889.n281 4.9251
R439 w_n656_n7889.n211 w_n656_n7889.n210 4.9251
R440 w_n656_n7889.n672 w_n656_n7889.n671 4.92413
R441 w_n656_n7889.n626 w_n656_n7889.n616 4.92413
R442 w_n656_n7889.n602 w_n656_n7889.n601 4.91528
R443 w_n656_n7889.n321 w_n656_n7889.n319 4.91528
R444 w_n656_n7889.n150 w_n656_n7889.n149 4.91528
R445 w_n656_n7889.n593 w_n656_n7889.n592 4.86343
R446 w_n656_n7889.n451 w_n656_n7889.n450 4.85463
R447 w_n656_n7889.n450 w_n656_n7889.n448 4.85463
R448 w_n656_n7889.n36 w_n656_n7889.n35 4.8155
R449 w_n656_n7889.n347 w_n656_n7889.n137 4.80376
R450 w_n656_n7889.n507 w_n656_n7889.n506 4.73528
R451 w_n656_n7889.n65 w_n656_n7889.n17 4.6445
R452 w_n656_n7889.n504 w_n656_n7889.n503 4.6445
R453 w_n656_n7889.n504 w_n656_n7889.n357 4.6445
R454 w_n656_n7889.n504 w_n656_n7889.n359 4.6445
R455 w_n656_n7889.n504 w_n656_n7889.n358 4.6445
R456 w_n656_n7889.n65 w_n656_n7889.n64 4.6445
R457 w_n656_n7889.n631 w_n656_n7889.n624 4.5005
R458 w_n656_n7889.n648 w_n656_n7889.n632 4.5005
R459 w_n656_n7889.n647 w_n656_n7889.n633 4.5005
R460 w_n656_n7889.n646 w_n656_n7889.n634 4.5005
R461 w_n656_n7889.n636 w_n656_n7889.n635 4.5005
R462 w_n656_n7889.n12 w_n656_n7889.n11 4.5005
R463 w_n656_n7889.n661 w_n656_n7889.n660 4.5005
R464 w_n656_n7889.n662 w_n656_n7889.n10 4.5005
R465 w_n656_n7889.n665 w_n656_n7889.n663 4.5005
R466 w_n656_n7889.n664 w_n656_n7889.n3 4.5005
R467 w_n656_n7889.n669 w_n656_n7889.n5 4.5005
R468 w_n656_n7889.n671 w_n656_n7889.n670 4.5005
R469 w_n656_n7889.n237 w_n656_n7889.n222 4.5005
R470 w_n656_n7889.n236 w_n656_n7889.n224 4.5005
R471 w_n656_n7889.n235 w_n656_n7889.n225 4.5005
R472 w_n656_n7889.n233 w_n656_n7889.n226 4.5005
R473 w_n656_n7889.n232 w_n656_n7889.n227 4.5005
R474 w_n656_n7889.n230 w_n656_n7889.n229 4.5005
R475 w_n656_n7889.n228 w_n656_n7889.n160 4.5005
R476 w_n656_n7889.n302 w_n656_n7889.n159 4.5005
R477 w_n656_n7889.n304 w_n656_n7889.n303 4.5005
R478 w_n656_n7889.n239 w_n656_n7889.n238 4.5005
R479 w_n656_n7889.n194 w_n656_n7889.n193 4.5005
R480 w_n656_n7889.n264 w_n656_n7889.n263 4.5005
R481 w_n656_n7889.n265 w_n656_n7889.n192 4.5005
R482 w_n656_n7889.n267 w_n656_n7889.n266 4.5005
R483 w_n656_n7889.n169 w_n656_n7889.n168 4.5005
R484 w_n656_n7889.n294 w_n656_n7889.n293 4.5005
R485 w_n656_n7889.n295 w_n656_n7889.n167 4.5005
R486 w_n656_n7889.n298 w_n656_n7889.n296 4.5005
R487 w_n656_n7889.n297 w_n656_n7889.n155 4.5005
R488 w_n656_n7889.n246 w_n656_n7889.n245 4.5005
R489 w_n656_n7889.n217 w_n656_n7889.n216 4.5005
R490 w_n656_n7889.n215 w_n656_n7889.n212 4.5005
R491 w_n656_n7889.n214 w_n656_n7889.n213 4.5005
R492 w_n656_n7889.n186 w_n656_n7889.n185 4.5005
R493 w_n656_n7889.n273 w_n656_n7889.n272 4.5005
R494 w_n656_n7889.n274 w_n656_n7889.n184 4.5005
R495 w_n656_n7889.n277 w_n656_n7889.n275 4.5005
R496 w_n656_n7889.n278 w_n656_n7889.n183 4.5005
R497 w_n656_n7889.n281 w_n656_n7889.n280 4.5005
R498 w_n656_n7889.n218 w_n656_n7889.n211 4.5005
R499 w_n656_n7889.n252 w_n656_n7889.n201 4.5005
R500 w_n656_n7889.n259 w_n656_n7889.n253 4.5005
R501 w_n656_n7889.n258 w_n656_n7889.n254 4.5005
R502 w_n656_n7889.n257 w_n656_n7889.n256 4.5005
R503 w_n656_n7889.n255 w_n656_n7889.n176 4.5005
R504 w_n656_n7889.n289 w_n656_n7889.n177 4.5005
R505 w_n656_n7889.n288 w_n656_n7889.n178 4.5005
R506 w_n656_n7889.n287 w_n656_n7889.n179 4.5005
R507 w_n656_n7889.n286 w_n656_n7889.n284 4.5005
R508 w_n656_n7889.n251 w_n656_n7889.n250 4.5005
R509 w_n656_n7889.n317 w_n656_n7889.n311 4.5005
R510 w_n656_n7889.n316 w_n656_n7889.n312 4.5005
R511 w_n656_n7889.n314 w_n656_n7889.n313 4.5005
R512 w_n656_n7889.n117 w_n656_n7889.n116 4.5005
R513 w_n656_n7889.n548 w_n656_n7889.n547 4.5005
R514 w_n656_n7889.n549 w_n656_n7889.n115 4.5005
R515 w_n656_n7889.n557 w_n656_n7889.n550 4.5005
R516 w_n656_n7889.n556 w_n656_n7889.n551 4.5005
R517 w_n656_n7889.n555 w_n656_n7889.n553 4.5005
R518 w_n656_n7889.n552 w_n656_n7889.n92 4.5005
R519 w_n656_n7889.n599 w_n656_n7889.n91 4.5005
R520 w_n656_n7889.n601 w_n656_n7889.n600 4.5005
R521 w_n656_n7889.n319 w_n656_n7889.n318 4.5005
R522 w_n656_n7889.n325 w_n656_n7889.n324 4.5005
R523 w_n656_n7889.n131 w_n656_n7889.n129 4.5005
R524 w_n656_n7889.n571 w_n656_n7889.n567 4.5005
R525 w_n656_n7889.n570 w_n656_n7889.n568 4.5005
R526 w_n656_n7889.n569 w_n656_n7889.n89 4.5005
R527 w_n656_n7889.n326 w_n656_n7889.n323 4.5005
R528 w_n656_n7889.n583 w_n656_n7889.n96 4.5005
R529 w_n656_n7889.n594 w_n656_n7889.n593 4.5005
R530 w_n656_n7889.n581 w_n656_n7889.n580 4.5005
R531 w_n656_n7889.n578 w_n656_n7889.n97 4.5005
R532 w_n656_n7889.n520 w_n656_n7889.n517 4.5005
R533 w_n656_n7889.n519 w_n656_n7889.n100 4.5005
R534 w_n656_n7889.n518 w_n656_n7889.n99 4.5005
R535 w_n656_n7889.n524 w_n656_n7889.n134 4.5005
R536 w_n656_n7889.n516 w_n656_n7889.n134 4.5005
R537 w_n656_n7889.n612 w_n656_n7889.n69 4.5005
R538 w_n656_n7889.n611 w_n656_n7889.n610 4.5005
R539 w_n656_n7889.n609 w_n656_n7889.n79 4.5005
R540 w_n656_n7889.n334 w_n656_n7889.n333 4.5005
R541 w_n656_n7889.n146 w_n656_n7889.n70 4.5005
R542 w_n656_n7889.n332 w_n656_n7889.n145 4.5005
R543 w_n656_n7889.n140 w_n656_n7889.n139 4.5005
R544 w_n656_n7889.n344 w_n656_n7889.n343 4.5005
R545 w_n656_n7889.n149 w_n656_n7889.n148 4.5005
R546 w_n656_n7889.n535 w_n656_n7889.n105 4.5005
R547 w_n656_n7889.n133 w_n656_n7889.n132 4.5005
R548 w_n656_n7889.n525 w_n656_n7889.n133 4.5005
R549 w_n656_n7889.n524 w_n656_n7889.n523 4.5005
R550 w_n656_n7889.n516 w_n656_n7889.n511 4.5005
R551 w_n656_n7889.n509 w_n656_n7889.n508 4.5005
R552 w_n656_n7889.n453 w_n656_n7889.n447 4.5005
R553 w_n656_n7889.n446 w_n656_n7889.n432 4.5005
R554 w_n656_n7889.n457 w_n656_n7889.n438 4.5005
R555 w_n656_n7889.n437 w_n656_n7889.n424 4.5005
R556 w_n656_n7889.n461 w_n656_n7889.n430 4.5005
R557 w_n656_n7889.n429 w_n656_n7889.n416 4.5005
R558 w_n656_n7889.n465 w_n656_n7889.n422 4.5005
R559 w_n656_n7889.n421 w_n656_n7889.n409 4.5005
R560 w_n656_n7889.n470 w_n656_n7889.n414 4.5005
R561 w_n656_n7889.n413 w_n656_n7889.n400 4.5005
R562 w_n656_n7889.n474 w_n656_n7889.n407 4.5005
R563 w_n656_n7889.n402 w_n656_n7889.n390 4.5005
R564 w_n656_n7889.n484 w_n656_n7889.n396 4.5005
R565 w_n656_n7889.n395 w_n656_n7889.n382 4.5005
R566 w_n656_n7889.n488 w_n656_n7889.n388 4.5005
R567 w_n656_n7889.n387 w_n656_n7889.n374 4.5005
R568 w_n656_n7889.n492 w_n656_n7889.n380 4.5005
R569 w_n656_n7889.n379 w_n656_n7889.n366 4.5005
R570 w_n656_n7889.n497 w_n656_n7889.n372 4.5005
R571 w_n656_n7889.n371 w_n656_n7889.n361 4.5005
R572 w_n656_n7889.n501 w_n656_n7889.n364 4.5005
R573 w_n656_n7889.n448 w_n656_n7889.n440 4.5005
R574 w_n656_n7889.n453 w_n656_n7889.n445 4.5005
R575 w_n656_n7889.n444 w_n656_n7889.n432 4.5005
R576 w_n656_n7889.n457 w_n656_n7889.n436 4.5005
R577 w_n656_n7889.n435 w_n656_n7889.n424 4.5005
R578 w_n656_n7889.n461 w_n656_n7889.n428 4.5005
R579 w_n656_n7889.n427 w_n656_n7889.n416 4.5005
R580 w_n656_n7889.n465 w_n656_n7889.n420 4.5005
R581 w_n656_n7889.n419 w_n656_n7889.n409 4.5005
R582 w_n656_n7889.n470 w_n656_n7889.n412 4.5005
R583 w_n656_n7889.n400 w_n656_n7889.n399 4.5005
R584 w_n656_n7889.n475 w_n656_n7889.n474 4.5005
R585 w_n656_n7889.n476 w_n656_n7889.n390 4.5005
R586 w_n656_n7889.n484 w_n656_n7889.n394 4.5005
R587 w_n656_n7889.n393 w_n656_n7889.n382 4.5005
R588 w_n656_n7889.n488 w_n656_n7889.n386 4.5005
R589 w_n656_n7889.n385 w_n656_n7889.n374 4.5005
R590 w_n656_n7889.n492 w_n656_n7889.n378 4.5005
R591 w_n656_n7889.n377 w_n656_n7889.n366 4.5005
R592 w_n656_n7889.n497 w_n656_n7889.n370 4.5005
R593 w_n656_n7889.n369 w_n656_n7889.n361 4.5005
R594 w_n656_n7889.n501 w_n656_n7889.n363 4.5005
R595 w_n656_n7889.n502 w_n656_n7889.n358 4.5005
R596 w_n656_n7889.n451 w_n656_n7889.n440 4.5005
R597 w_n656_n7889.n453 w_n656_n7889.n452 4.5005
R598 w_n656_n7889.n432 w_n656_n7889.n431 4.5005
R599 w_n656_n7889.n458 w_n656_n7889.n457 4.5005
R600 w_n656_n7889.n459 w_n656_n7889.n424 4.5005
R601 w_n656_n7889.n461 w_n656_n7889.n460 4.5005
R602 w_n656_n7889.n416 w_n656_n7889.n415 4.5005
R603 w_n656_n7889.n466 w_n656_n7889.n465 4.5005
R604 w_n656_n7889.n467 w_n656_n7889.n409 4.5005
R605 w_n656_n7889.n470 w_n656_n7889.n469 4.5005
R606 w_n656_n7889.n468 w_n656_n7889.n400 4.5005
R607 w_n656_n7889.n474 w_n656_n7889.n397 4.5005
R608 w_n656_n7889.n482 w_n656_n7889.n390 4.5005
R609 w_n656_n7889.n484 w_n656_n7889.n483 4.5005
R610 w_n656_n7889.n382 w_n656_n7889.n381 4.5005
R611 w_n656_n7889.n489 w_n656_n7889.n488 4.5005
R612 w_n656_n7889.n490 w_n656_n7889.n374 4.5005
R613 w_n656_n7889.n492 w_n656_n7889.n491 4.5005
R614 w_n656_n7889.n366 w_n656_n7889.n365 4.5005
R615 w_n656_n7889.n498 w_n656_n7889.n497 4.5005
R616 w_n656_n7889.n499 w_n656_n7889.n361 4.5005
R617 w_n656_n7889.n501 w_n656_n7889.n500 4.5005
R618 w_n656_n7889.n502 w_n656_n7889.n359 4.5005
R619 w_n656_n7889.n441 w_n656_n7889.n440 4.5005
R620 w_n656_n7889.n453 w_n656_n7889.n443 4.5005
R621 w_n656_n7889.n442 w_n656_n7889.n432 4.5005
R622 w_n656_n7889.n457 w_n656_n7889.n434 4.5005
R623 w_n656_n7889.n433 w_n656_n7889.n424 4.5005
R624 w_n656_n7889.n461 w_n656_n7889.n426 4.5005
R625 w_n656_n7889.n425 w_n656_n7889.n416 4.5005
R626 w_n656_n7889.n465 w_n656_n7889.n418 4.5005
R627 w_n656_n7889.n417 w_n656_n7889.n409 4.5005
R628 w_n656_n7889.n470 w_n656_n7889.n411 4.5005
R629 w_n656_n7889.n410 w_n656_n7889.n400 4.5005
R630 w_n656_n7889.n474 w_n656_n7889.n401 4.5005
R631 w_n656_n7889.n403 w_n656_n7889.n390 4.5005
R632 w_n656_n7889.n484 w_n656_n7889.n392 4.5005
R633 w_n656_n7889.n391 w_n656_n7889.n382 4.5005
R634 w_n656_n7889.n488 w_n656_n7889.n384 4.5005
R635 w_n656_n7889.n383 w_n656_n7889.n374 4.5005
R636 w_n656_n7889.n492 w_n656_n7889.n376 4.5005
R637 w_n656_n7889.n375 w_n656_n7889.n366 4.5005
R638 w_n656_n7889.n497 w_n656_n7889.n368 4.5005
R639 w_n656_n7889.n367 w_n656_n7889.n361 4.5005
R640 w_n656_n7889.n501 w_n656_n7889.n362 4.5005
R641 w_n656_n7889.n502 w_n656_n7889.n357 4.5005
R642 w_n656_n7889.n440 w_n656_n7889.n439 4.5005
R643 w_n656_n7889.n454 w_n656_n7889.n453 4.5005
R644 w_n656_n7889.n455 w_n656_n7889.n432 4.5005
R645 w_n656_n7889.n457 w_n656_n7889.n456 4.5005
R646 w_n656_n7889.n424 w_n656_n7889.n423 4.5005
R647 w_n656_n7889.n462 w_n656_n7889.n461 4.5005
R648 w_n656_n7889.n463 w_n656_n7889.n416 4.5005
R649 w_n656_n7889.n465 w_n656_n7889.n464 4.5005
R650 w_n656_n7889.n409 w_n656_n7889.n408 4.5005
R651 w_n656_n7889.n471 w_n656_n7889.n470 4.5005
R652 w_n656_n7889.n472 w_n656_n7889.n400 4.5005
R653 w_n656_n7889.n474 w_n656_n7889.n473 4.5005
R654 w_n656_n7889.n390 w_n656_n7889.n389 4.5005
R655 w_n656_n7889.n485 w_n656_n7889.n484 4.5005
R656 w_n656_n7889.n486 w_n656_n7889.n382 4.5005
R657 w_n656_n7889.n488 w_n656_n7889.n487 4.5005
R658 w_n656_n7889.n374 w_n656_n7889.n373 4.5005
R659 w_n656_n7889.n493 w_n656_n7889.n492 4.5005
R660 w_n656_n7889.n494 w_n656_n7889.n366 4.5005
R661 w_n656_n7889.n497 w_n656_n7889.n496 4.5005
R662 w_n656_n7889.n495 w_n656_n7889.n361 4.5005
R663 w_n656_n7889.n501 w_n656_n7889.n360 4.5005
R664 w_n656_n7889.n503 w_n656_n7889.n502 4.5005
R665 w_n656_n7889.n39 w_n656_n7889.n38 4.5005
R666 w_n656_n7889.n29 w_n656_n7889.n28 4.5005
R667 w_n656_n7889.n45 w_n656_n7889.n44 4.5005
R668 w_n656_n7889.n46 w_n656_n7889.n27 4.5005
R669 w_n656_n7889.n49 w_n656_n7889.n48 4.5005
R670 w_n656_n7889.n22 w_n656_n7889.n21 4.5005
R671 w_n656_n7889.n59 w_n656_n7889.n58 4.5005
R672 w_n656_n7889.n60 w_n656_n7889.n19 4.5005
R673 w_n656_n7889.n62 w_n656_n7889.n61 4.5005
R674 w_n656_n7889.n35 w_n656_n7889.n32 4.5005
R675 w_n656_n7889.n39 w_n656_n7889.n34 4.5005
R676 w_n656_n7889.n33 w_n656_n7889.n29 4.5005
R677 w_n656_n7889.n44 w_n656_n7889.n30 4.5005
R678 w_n656_n7889.n27 w_n656_n7889.n26 4.5005
R679 w_n656_n7889.n50 w_n656_n7889.n49 4.5005
R680 w_n656_n7889.n51 w_n656_n7889.n22 4.5005
R681 w_n656_n7889.n58 w_n656_n7889.n24 4.5005
R682 w_n656_n7889.n23 w_n656_n7889.n19 4.5005
R683 w_n656_n7889.n62 w_n656_n7889.n20 4.5005
R684 w_n656_n7889.n63 w_n656_n7889.n17 4.5005
R685 w_n656_n7889.n32 w_n656_n7889.n31 4.5005
R686 w_n656_n7889.n40 w_n656_n7889.n39 4.5005
R687 w_n656_n7889.n41 w_n656_n7889.n29 4.5005
R688 w_n656_n7889.n44 w_n656_n7889.n43 4.5005
R689 w_n656_n7889.n42 w_n656_n7889.n27 4.5005
R690 w_n656_n7889.n49 w_n656_n7889.n25 4.5005
R691 w_n656_n7889.n55 w_n656_n7889.n22 4.5005
R692 w_n656_n7889.n58 w_n656_n7889.n57 4.5005
R693 w_n656_n7889.n56 w_n656_n7889.n19 4.5005
R694 w_n656_n7889.n62 w_n656_n7889.n18 4.5005
R695 w_n656_n7889.n64 w_n656_n7889.n63 4.5005
R696 w_n656_n7889.n505 w_n656_n7889.n138 4.5005
R697 w_n656_n7889.n614 w_n656_n7889.n613 4.5005
R698 w_n656_n7889.n653 w_n656_n7889.n652 4.5005
R699 w_n656_n7889.n617 w_n656_n7889.n616 4.5005
R700 w_n656_n7889.n628 w_n656_n7889.n619 3.97982
R701 w_n656_n7889.t7 w_n656_n7889.n108 3.62311
R702 w_n656_n7889.n354 w_n656_n7889.n348 2.4825
R703 w_n656_n7889.n353 w_n656_n7889.n352 2.4825
R704 w_n656_n7889.n449 w_n656_n7889.n447 2.472
R705 w_n656_n7889.n38 w_n656_n7889.n37 2.46378
R706 w_n656_n7889.n61 w_n656_n7889.n16 2.42688
R707 w_n656_n7889.n364 w_n656_n7889.n356 2.42688
R708 w_n656_n7889.n513 w_n656_n7889.n101 2.32932
R709 w_n656_n7889.n589 w_n656_n7889.n586 2.32769
R710 w_n656_n7889.n522 w_n656_n7889.n510 2.2884
R711 w_n656_n7889.n566 w_n656_n7889.n565 2.21557
R712 w_n656_n7889.n536 w_n656_n7889.n535 2.21557
R713 w_n656_n7889.n535 w_n656_n7889.n534 2.21557
R714 w_n656_n7889.n341 w_n656_n7889.n133 2.21557
R715 w_n656_n7889.n527 w_n656_n7889.n133 2.21557
R716 w_n656_n7889.n614 w_n656_n7889.n72 2.21557
R717 w_n656_n7889.n614 w_n656_n7889.n73 2.21557
R718 w_n656_n7889.n614 w_n656_n7889.n74 2.21557
R719 w_n656_n7889.n654 w_n656_n7889.n615 2.21557
R720 w_n656_n7889.n654 w_n656_n7889.n68 2.21557
R721 w_n656_n7889.n655 w_n656_n7889.n654 2.21557
R722 w_n656_n7889.n603 w_n656_n7889.n602 2.18007
R723 w_n656_n7889.n322 w_n656_n7889.n321 2.18007
R724 w_n656_n7889.n331 w_n656_n7889.n150 2.18007
R725 w_n656_n7889.n590 w_n656_n7889.n585 2.16845
R726 w_n656_n7889.n628 w_n656_n7889.n627 2.15819
R727 w_n656_n7889.n562 w_n656_n7889.n108 2.07056
R728 w_n656_n7889.n597 w_n656_n7889.n596 2.07056
R729 w_n656_n7889.n82 w_n656_n7889.n80 1.78197
R730 w_n656_n7889.n591 w_n656_n7889.n82 1.59006
R731 w_n656_n7889.n351 w_n656_n7889.n350 1.3875
R732 w_n656_n7889.n673 w_n656_n7889.n672 1.20278
R733 w_n656_n7889.n630 w_n656_n7889.n626 1.20278
R734 w_n656_n7889.n90 w_n656_n7889.t19 1.14729
R735 w_n656_n7889.n320 w_n656_n7889.t21 1.14729
R736 w_n656_n7889.n147 w_n656_n7889.t17 1.14729
R737 w_n656_n7889.n158 w_n656_n7889.n157 1.00876
R738 w_n656_n7889.n242 w_n656_n7889.n241 1.00876
R739 w_n656_n7889.n182 w_n656_n7889.n181 1.00876
R740 w_n656_n7889.n209 w_n656_n7889.n208 1.00876
R741 w_n656_n7889.n608 w_n656_n7889.n80 1.00517
R742 w_n656_n7889.n4 w_n656_n7889.t33 0.794109
R743 w_n656_n7889.n625 w_n656_n7889.t24 0.794109
R744 w_n656_n7889.t27 w_n656_n7889.n52 0.5615
R745 w_n656_n7889.n47 w_n656_n7889.t30 0.5615
R746 w_n656_n7889.n306 w_n656_n7889.n305 0.518
R747 w_n656_n7889.n244 w_n656_n7889.n243 0.518
R748 w_n656_n7889.n283 w_n656_n7889.n282 0.518
R749 w_n656_n7889.n210 w_n656_n7889.n202 0.518
R750 w_n656_n7889.n203 w_n656_n7889.n202 0.371929
R751 w_n656_n7889.n204 w_n656_n7889.n203 0.371929
R752 w_n656_n7889.n283 w_n656_n7889.n152 0.371929
R753 w_n656_n7889.n308 w_n656_n7889.n152 0.371929
R754 w_n656_n7889.n244 w_n656_n7889.n221 0.371929
R755 w_n656_n7889.n221 w_n656_n7889.n204 0.371929
R756 w_n656_n7889.n307 w_n656_n7889.n306 0.371929
R757 w_n656_n7889.n308 w_n656_n7889.n307 0.371929
R758 w_n656_n7889.n481 w_n656_n7889.t8 0.369967
R759 w_n656_n7889.n520 w_n656_n7889.n104 0.328203
R760 w_n656_n7889.n355 w_n656_n7889.n347 0.313543
R761 w_n656_n7889.n53 w_n656_n7889.t30 0.3015
R762 w_n656_n7889.n53 w_n656_n7889.t27 0.3015
R763 w_n656_n7889.n406 w_n656_n7889.t11 0.289609
R764 w_n656_n7889.n602 w_n656_n7889.n90 0.283087
R765 w_n656_n7889.n321 w_n656_n7889.n320 0.283087
R766 w_n656_n7889.n150 w_n656_n7889.n147 0.283087
R767 w_n656_n7889.n305 w_n656_n7889.n158 0.28275
R768 w_n656_n7889.n243 w_n656_n7889.n242 0.28275
R769 w_n656_n7889.n282 w_n656_n7889.n182 0.28275
R770 w_n656_n7889.n210 w_n656_n7889.n209 0.28275
R771 w_n656_n7889.n672 w_n656_n7889.n4 0.282011
R772 w_n656_n7889.n626 w_n656_n7889.n625 0.282011
R773 w_n656_n7889.n54 w_n656_n7889.n53 0.2605
R774 w_n656_n7889.n506 w_n656_n7889.n345 0.260273
R775 w_n656_n7889.n608 w_n656_n7889.n607 0.236864
R776 w_n656_n7889.n509 w_n656_n7889.n136 0.235045
R777 w_n656_n7889.n607 w_n656_n7889.n606 0.232564
R778 w_n656_n7889.n630 w_n656_n7889.n629 0.217741
R779 w_n656_n7889.n674 w_n656_n7889.n673 0.217741
R780 w_n656_n7889.n675 w_n656_n7889.n674 0.217741
R781 w_n656_n7889.n591 w_n656_n7889.n590 0.217674
R782 w_n656_n7889.n566 w_n656_n7889.n104 0.192557
R783 w_n656_n7889.n479 w_n656_n7889.n398 0.16497
R784 w_n656_n7889.n507 w_n656_n7889.n138 0.16353
R785 w_n656_n7889.n508 w_n656_n7889.n507 0.16353
R786 w_n656_n7889.n405 w_n656_n7889.n404 0.154159
R787 w_n656_n7889.n478 w_n656_n7889.n477 0.154159
R788 w_n656_n7889.n648 w_n656_n7889.n624 0.1445
R789 w_n656_n7889.n648 w_n656_n7889.n647 0.1445
R790 w_n656_n7889.n647 w_n656_n7889.n646 0.1445
R791 w_n656_n7889.n646 w_n656_n7889.n636 0.1445
R792 w_n656_n7889.n636 w_n656_n7889.n12 0.1445
R793 w_n656_n7889.n660 w_n656_n7889.n12 0.1445
R794 w_n656_n7889.n660 w_n656_n7889.n10 0.1445
R795 w_n656_n7889.n665 w_n656_n7889.n10 0.1445
R796 w_n656_n7889.n665 w_n656_n7889.n664 0.1445
R797 w_n656_n7889.n632 w_n656_n7889.n631 0.1445
R798 w_n656_n7889.n633 w_n656_n7889.n632 0.1445
R799 w_n656_n7889.n634 w_n656_n7889.n633 0.1445
R800 w_n656_n7889.n635 w_n656_n7889.n634 0.1445
R801 w_n656_n7889.n635 w_n656_n7889.n11 0.1445
R802 w_n656_n7889.n661 w_n656_n7889.n11 0.1445
R803 w_n656_n7889.n662 w_n656_n7889.n661 0.1445
R804 w_n656_n7889.n663 w_n656_n7889.n662 0.1445
R805 w_n656_n7889.n663 w_n656_n7889.n3 0.1445
R806 w_n656_n7889.n671 w_n656_n7889.n5 0.1445
R807 w_n656_n7889.n652 w_n656_n7889.n617 0.1445
R808 w_n656_n7889.n652 w_n656_n7889.n618 0.1445
R809 w_n656_n7889.n640 w_n656_n7889.n639 0.1445
R810 w_n656_n7889.n656 w_n656_n7889.n15 0.1445
R811 w_n656_n7889.n669 w_n656_n7889.n6 0.1445
R812 w_n656_n7889.n670 w_n656_n7889.n669 0.1445
R813 w_n656_n7889.n35 w_n656_n7889.n34 0.1445
R814 w_n656_n7889.n34 w_n656_n7889.n33 0.1445
R815 w_n656_n7889.n33 w_n656_n7889.n30 0.1445
R816 w_n656_n7889.n30 w_n656_n7889.n26 0.1445
R817 w_n656_n7889.n50 w_n656_n7889.n26 0.1445
R818 w_n656_n7889.n51 w_n656_n7889.n24 0.1445
R819 w_n656_n7889.n24 w_n656_n7889.n23 0.1445
R820 w_n656_n7889.n23 w_n656_n7889.n20 0.1445
R821 w_n656_n7889.n20 w_n656_n7889.n17 0.1445
R822 w_n656_n7889.n38 w_n656_n7889.n28 0.1445
R823 w_n656_n7889.n45 w_n656_n7889.n28 0.1445
R824 w_n656_n7889.n46 w_n656_n7889.n45 0.1445
R825 w_n656_n7889.n48 w_n656_n7889.n46 0.1445
R826 w_n656_n7889.n59 w_n656_n7889.n21 0.1445
R827 w_n656_n7889.n60 w_n656_n7889.n59 0.1445
R828 w_n656_n7889.n61 w_n656_n7889.n60 0.1445
R829 w_n656_n7889.n454 w_n656_n7889.n439 0.1445
R830 w_n656_n7889.n455 w_n656_n7889.n454 0.1445
R831 w_n656_n7889.n456 w_n656_n7889.n455 0.1445
R832 w_n656_n7889.n456 w_n656_n7889.n423 0.1445
R833 w_n656_n7889.n462 w_n656_n7889.n423 0.1445
R834 w_n656_n7889.n463 w_n656_n7889.n462 0.1445
R835 w_n656_n7889.n464 w_n656_n7889.n463 0.1445
R836 w_n656_n7889.n464 w_n656_n7889.n408 0.1445
R837 w_n656_n7889.n471 w_n656_n7889.n408 0.1445
R838 w_n656_n7889.n472 w_n656_n7889.n471 0.1445
R839 w_n656_n7889.n473 w_n656_n7889.n472 0.1445
R840 w_n656_n7889.n485 w_n656_n7889.n389 0.1445
R841 w_n656_n7889.n486 w_n656_n7889.n485 0.1445
R842 w_n656_n7889.n487 w_n656_n7889.n486 0.1445
R843 w_n656_n7889.n487 w_n656_n7889.n373 0.1445
R844 w_n656_n7889.n493 w_n656_n7889.n373 0.1445
R845 w_n656_n7889.n494 w_n656_n7889.n493 0.1445
R846 w_n656_n7889.n496 w_n656_n7889.n494 0.1445
R847 w_n656_n7889.n496 w_n656_n7889.n495 0.1445
R848 w_n656_n7889.n495 w_n656_n7889.n360 0.1445
R849 w_n656_n7889.n503 w_n656_n7889.n360 0.1445
R850 w_n656_n7889.n443 w_n656_n7889.n441 0.1445
R851 w_n656_n7889.n443 w_n656_n7889.n442 0.1445
R852 w_n656_n7889.n442 w_n656_n7889.n434 0.1445
R853 w_n656_n7889.n434 w_n656_n7889.n433 0.1445
R854 w_n656_n7889.n433 w_n656_n7889.n426 0.1445
R855 w_n656_n7889.n426 w_n656_n7889.n425 0.1445
R856 w_n656_n7889.n425 w_n656_n7889.n418 0.1445
R857 w_n656_n7889.n418 w_n656_n7889.n417 0.1445
R858 w_n656_n7889.n417 w_n656_n7889.n411 0.1445
R859 w_n656_n7889.n411 w_n656_n7889.n410 0.1445
R860 w_n656_n7889.n410 w_n656_n7889.n401 0.1445
R861 w_n656_n7889.n403 w_n656_n7889.n392 0.1445
R862 w_n656_n7889.n392 w_n656_n7889.n391 0.1445
R863 w_n656_n7889.n391 w_n656_n7889.n384 0.1445
R864 w_n656_n7889.n384 w_n656_n7889.n383 0.1445
R865 w_n656_n7889.n383 w_n656_n7889.n376 0.1445
R866 w_n656_n7889.n376 w_n656_n7889.n375 0.1445
R867 w_n656_n7889.n375 w_n656_n7889.n368 0.1445
R868 w_n656_n7889.n368 w_n656_n7889.n367 0.1445
R869 w_n656_n7889.n367 w_n656_n7889.n362 0.1445
R870 w_n656_n7889.n362 w_n656_n7889.n357 0.1445
R871 w_n656_n7889.n452 w_n656_n7889.n451 0.1445
R872 w_n656_n7889.n452 w_n656_n7889.n431 0.1445
R873 w_n656_n7889.n458 w_n656_n7889.n431 0.1445
R874 w_n656_n7889.n459 w_n656_n7889.n458 0.1445
R875 w_n656_n7889.n460 w_n656_n7889.n459 0.1445
R876 w_n656_n7889.n460 w_n656_n7889.n415 0.1445
R877 w_n656_n7889.n466 w_n656_n7889.n415 0.1445
R878 w_n656_n7889.n467 w_n656_n7889.n466 0.1445
R879 w_n656_n7889.n469 w_n656_n7889.n467 0.1445
R880 w_n656_n7889.n469 w_n656_n7889.n468 0.1445
R881 w_n656_n7889.n468 w_n656_n7889.n397 0.1445
R882 w_n656_n7889.n483 w_n656_n7889.n482 0.1445
R883 w_n656_n7889.n483 w_n656_n7889.n381 0.1445
R884 w_n656_n7889.n489 w_n656_n7889.n381 0.1445
R885 w_n656_n7889.n490 w_n656_n7889.n489 0.1445
R886 w_n656_n7889.n491 w_n656_n7889.n490 0.1445
R887 w_n656_n7889.n491 w_n656_n7889.n365 0.1445
R888 w_n656_n7889.n498 w_n656_n7889.n365 0.1445
R889 w_n656_n7889.n499 w_n656_n7889.n498 0.1445
R890 w_n656_n7889.n500 w_n656_n7889.n499 0.1445
R891 w_n656_n7889.n500 w_n656_n7889.n359 0.1445
R892 w_n656_n7889.n448 w_n656_n7889.n445 0.1445
R893 w_n656_n7889.n445 w_n656_n7889.n444 0.1445
R894 w_n656_n7889.n444 w_n656_n7889.n436 0.1445
R895 w_n656_n7889.n436 w_n656_n7889.n435 0.1445
R896 w_n656_n7889.n435 w_n656_n7889.n428 0.1445
R897 w_n656_n7889.n428 w_n656_n7889.n427 0.1445
R898 w_n656_n7889.n427 w_n656_n7889.n420 0.1445
R899 w_n656_n7889.n420 w_n656_n7889.n419 0.1445
R900 w_n656_n7889.n419 w_n656_n7889.n412 0.1445
R901 w_n656_n7889.n412 w_n656_n7889.n399 0.1445
R902 w_n656_n7889.n475 w_n656_n7889.n399 0.1445
R903 w_n656_n7889.n476 w_n656_n7889.n394 0.1445
R904 w_n656_n7889.n394 w_n656_n7889.n393 0.1445
R905 w_n656_n7889.n393 w_n656_n7889.n386 0.1445
R906 w_n656_n7889.n386 w_n656_n7889.n385 0.1445
R907 w_n656_n7889.n385 w_n656_n7889.n378 0.1445
R908 w_n656_n7889.n378 w_n656_n7889.n377 0.1445
R909 w_n656_n7889.n377 w_n656_n7889.n370 0.1445
R910 w_n656_n7889.n370 w_n656_n7889.n369 0.1445
R911 w_n656_n7889.n369 w_n656_n7889.n363 0.1445
R912 w_n656_n7889.n363 w_n656_n7889.n358 0.1445
R913 w_n656_n7889.n447 w_n656_n7889.n446 0.1445
R914 w_n656_n7889.n446 w_n656_n7889.n438 0.1445
R915 w_n656_n7889.n438 w_n656_n7889.n437 0.1445
R916 w_n656_n7889.n437 w_n656_n7889.n430 0.1445
R917 w_n656_n7889.n430 w_n656_n7889.n429 0.1445
R918 w_n656_n7889.n429 w_n656_n7889.n422 0.1445
R919 w_n656_n7889.n422 w_n656_n7889.n421 0.1445
R920 w_n656_n7889.n421 w_n656_n7889.n414 0.1445
R921 w_n656_n7889.n414 w_n656_n7889.n413 0.1445
R922 w_n656_n7889.n413 w_n656_n7889.n407 0.1445
R923 w_n656_n7889.n402 w_n656_n7889.n396 0.1445
R924 w_n656_n7889.n396 w_n656_n7889.n395 0.1445
R925 w_n656_n7889.n395 w_n656_n7889.n388 0.1445
R926 w_n656_n7889.n388 w_n656_n7889.n387 0.1445
R927 w_n656_n7889.n387 w_n656_n7889.n380 0.1445
R928 w_n656_n7889.n380 w_n656_n7889.n379 0.1445
R929 w_n656_n7889.n379 w_n656_n7889.n372 0.1445
R930 w_n656_n7889.n372 w_n656_n7889.n371 0.1445
R931 w_n656_n7889.n371 w_n656_n7889.n364 0.1445
R932 w_n656_n7889.n40 w_n656_n7889.n31 0.1445
R933 w_n656_n7889.n41 w_n656_n7889.n40 0.1445
R934 w_n656_n7889.n43 w_n656_n7889.n41 0.1445
R935 w_n656_n7889.n43 w_n656_n7889.n42 0.1445
R936 w_n656_n7889.n42 w_n656_n7889.n25 0.1445
R937 w_n656_n7889.n57 w_n656_n7889.n55 0.1445
R938 w_n656_n7889.n57 w_n656_n7889.n56 0.1445
R939 w_n656_n7889.n56 w_n656_n7889.n18 0.1445
R940 w_n656_n7889.n64 w_n656_n7889.n18 0.1445
R941 w_n656_n7889.n238 w_n656_n7889.n237 0.1445
R942 w_n656_n7889.n237 w_n656_n7889.n236 0.1445
R943 w_n656_n7889.n236 w_n656_n7889.n235 0.1445
R944 w_n656_n7889.n235 w_n656_n7889.n233 0.1445
R945 w_n656_n7889.n233 w_n656_n7889.n232 0.1445
R946 w_n656_n7889.n232 w_n656_n7889.n230 0.1445
R947 w_n656_n7889.n230 w_n656_n7889.n160 0.1445
R948 w_n656_n7889.n302 w_n656_n7889.n160 0.1445
R949 w_n656_n7889.n303 w_n656_n7889.n302 0.1445
R950 w_n656_n7889.n239 w_n656_n7889.n222 0.1445
R951 w_n656_n7889.n224 w_n656_n7889.n222 0.1445
R952 w_n656_n7889.n225 w_n656_n7889.n224 0.1445
R953 w_n656_n7889.n226 w_n656_n7889.n225 0.1445
R954 w_n656_n7889.n227 w_n656_n7889.n226 0.1445
R955 w_n656_n7889.n229 w_n656_n7889.n227 0.1445
R956 w_n656_n7889.n229 w_n656_n7889.n228 0.1445
R957 w_n656_n7889.n228 w_n656_n7889.n159 0.1445
R958 w_n656_n7889.n304 w_n656_n7889.n159 0.1445
R959 w_n656_n7889.n245 w_n656_n7889.n193 0.1445
R960 w_n656_n7889.n264 w_n656_n7889.n193 0.1445
R961 w_n656_n7889.n265 w_n656_n7889.n264 0.1445
R962 w_n656_n7889.n266 w_n656_n7889.n265 0.1445
R963 w_n656_n7889.n266 w_n656_n7889.n168 0.1445
R964 w_n656_n7889.n294 w_n656_n7889.n168 0.1445
R965 w_n656_n7889.n295 w_n656_n7889.n294 0.1445
R966 w_n656_n7889.n296 w_n656_n7889.n295 0.1445
R967 w_n656_n7889.n296 w_n656_n7889.n155 0.1445
R968 w_n656_n7889.n246 w_n656_n7889.n194 0.1445
R969 w_n656_n7889.n263 w_n656_n7889.n194 0.1445
R970 w_n656_n7889.n263 w_n656_n7889.n192 0.1445
R971 w_n656_n7889.n267 w_n656_n7889.n192 0.1445
R972 w_n656_n7889.n267 w_n656_n7889.n169 0.1445
R973 w_n656_n7889.n293 w_n656_n7889.n169 0.1445
R974 w_n656_n7889.n293 w_n656_n7889.n167 0.1445
R975 w_n656_n7889.n298 w_n656_n7889.n167 0.1445
R976 w_n656_n7889.n298 w_n656_n7889.n297 0.1445
R977 w_n656_n7889.n218 w_n656_n7889.n217 0.1445
R978 w_n656_n7889.n217 w_n656_n7889.n212 0.1445
R979 w_n656_n7889.n213 w_n656_n7889.n212 0.1445
R980 w_n656_n7889.n213 w_n656_n7889.n186 0.1445
R981 w_n656_n7889.n272 w_n656_n7889.n186 0.1445
R982 w_n656_n7889.n272 w_n656_n7889.n184 0.1445
R983 w_n656_n7889.n277 w_n656_n7889.n184 0.1445
R984 w_n656_n7889.n278 w_n656_n7889.n277 0.1445
R985 w_n656_n7889.n280 w_n656_n7889.n278 0.1445
R986 w_n656_n7889.n216 w_n656_n7889.n211 0.1445
R987 w_n656_n7889.n216 w_n656_n7889.n215 0.1445
R988 w_n656_n7889.n215 w_n656_n7889.n214 0.1445
R989 w_n656_n7889.n214 w_n656_n7889.n185 0.1445
R990 w_n656_n7889.n273 w_n656_n7889.n185 0.1445
R991 w_n656_n7889.n274 w_n656_n7889.n273 0.1445
R992 w_n656_n7889.n275 w_n656_n7889.n274 0.1445
R993 w_n656_n7889.n275 w_n656_n7889.n183 0.1445
R994 w_n656_n7889.n281 w_n656_n7889.n183 0.1445
R995 w_n656_n7889.n252 w_n656_n7889.n251 0.1445
R996 w_n656_n7889.n253 w_n656_n7889.n252 0.1445
R997 w_n656_n7889.n254 w_n656_n7889.n253 0.1445
R998 w_n656_n7889.n256 w_n656_n7889.n254 0.1445
R999 w_n656_n7889.n256 w_n656_n7889.n255 0.1445
R1000 w_n656_n7889.n255 w_n656_n7889.n177 0.1445
R1001 w_n656_n7889.n178 w_n656_n7889.n177 0.1445
R1002 w_n656_n7889.n179 w_n656_n7889.n178 0.1445
R1003 w_n656_n7889.n284 w_n656_n7889.n179 0.1445
R1004 w_n656_n7889.n250 w_n656_n7889.n201 0.1445
R1005 w_n656_n7889.n259 w_n656_n7889.n201 0.1445
R1006 w_n656_n7889.n259 w_n656_n7889.n258 0.1445
R1007 w_n656_n7889.n258 w_n656_n7889.n257 0.1445
R1008 w_n656_n7889.n257 w_n656_n7889.n176 0.1445
R1009 w_n656_n7889.n289 w_n656_n7889.n176 0.1445
R1010 w_n656_n7889.n289 w_n656_n7889.n288 0.1445
R1011 w_n656_n7889.n288 w_n656_n7889.n287 0.1445
R1012 w_n656_n7889.n287 w_n656_n7889.n286 0.1445
R1013 w_n656_n7889.n318 w_n656_n7889.n317 0.1445
R1014 w_n656_n7889.n317 w_n656_n7889.n316 0.1445
R1015 w_n656_n7889.n316 w_n656_n7889.n314 0.1445
R1016 w_n656_n7889.n314 w_n656_n7889.n117 0.1445
R1017 w_n656_n7889.n547 w_n656_n7889.n117 0.1445
R1018 w_n656_n7889.n547 w_n656_n7889.n115 0.1445
R1019 w_n656_n7889.n557 w_n656_n7889.n115 0.1445
R1020 w_n656_n7889.n557 w_n656_n7889.n556 0.1445
R1021 w_n656_n7889.n556 w_n656_n7889.n555 0.1445
R1022 w_n656_n7889.n555 w_n656_n7889.n92 0.1445
R1023 w_n656_n7889.n599 w_n656_n7889.n92 0.1445
R1024 w_n656_n7889.n600 w_n656_n7889.n599 0.1445
R1025 w_n656_n7889.n610 w_n656_n7889.n69 0.1445
R1026 w_n656_n7889.n610 w_n656_n7889.n609 0.1445
R1027 w_n656_n7889.n568 w_n656_n7889.n567 0.1445
R1028 w_n656_n7889.n568 w_n656_n7889.n89 0.1445
R1029 w_n656_n7889.n319 w_n656_n7889.n311 0.1445
R1030 w_n656_n7889.n312 w_n656_n7889.n311 0.1445
R1031 w_n656_n7889.n313 w_n656_n7889.n312 0.1445
R1032 w_n656_n7889.n313 w_n656_n7889.n116 0.1445
R1033 w_n656_n7889.n548 w_n656_n7889.n116 0.1445
R1034 w_n656_n7889.n549 w_n656_n7889.n548 0.1445
R1035 w_n656_n7889.n550 w_n656_n7889.n549 0.1445
R1036 w_n656_n7889.n551 w_n656_n7889.n550 0.1445
R1037 w_n656_n7889.n553 w_n656_n7889.n551 0.1445
R1038 w_n656_n7889.n553 w_n656_n7889.n552 0.1445
R1039 w_n656_n7889.n552 w_n656_n7889.n91 0.1445
R1040 w_n656_n7889.n601 w_n656_n7889.n91 0.1445
R1041 w_n656_n7889.n324 w_n656_n7889.n323 0.1445
R1042 w_n656_n7889.n324 w_n656_n7889.n131 0.1445
R1043 w_n656_n7889.n326 w_n656_n7889.n325 0.1445
R1044 w_n656_n7889.n325 w_n656_n7889.n129 0.1445
R1045 w_n656_n7889.n537 w_n656_n7889.n129 0.1445
R1046 w_n656_n7889.n533 w_n656_n7889.n130 0.1445
R1047 w_n656_n7889.n532 w_n656_n7889.n105 0.1445
R1048 w_n656_n7889.n564 w_n656_n7889.n105 0.1445
R1049 w_n656_n7889.n571 w_n656_n7889.n103 0.1445
R1050 w_n656_n7889.n571 w_n656_n7889.n570 0.1445
R1051 w_n656_n7889.n570 w_n656_n7889.n569 0.1445
R1052 w_n656_n7889.n148 w_n656_n7889.n140 0.1445
R1053 w_n656_n7889.n343 w_n656_n7889.n140 0.1445
R1054 w_n656_n7889.n343 w_n656_n7889.n342 0.1445
R1055 w_n656_n7889.n340 w_n656_n7889.n132 0.1445
R1056 w_n656_n7889.n528 w_n656_n7889.n132 0.1445
R1057 w_n656_n7889.n334 w_n656_n7889.n145 0.1445
R1058 w_n656_n7889.n334 w_n656_n7889.n146 0.1445
R1059 w_n656_n7889.n146 w_n656_n7889.n123 0.1445
R1060 w_n656_n7889.n543 w_n656_n7889.n542 0.1445
R1061 w_n656_n7889.n112 w_n656_n7889.n111 0.1445
R1062 w_n656_n7889.n613 w_n656_n7889.n75 0.1445
R1063 w_n656_n7889.n613 w_n656_n7889.n612 0.1445
R1064 w_n656_n7889.n612 w_n656_n7889.n611 0.1445
R1065 w_n656_n7889.n611 w_n656_n7889.n79 0.1445
R1066 w_n656_n7889.n333 w_n656_n7889.n332 0.1445
R1067 w_n656_n7889.n333 w_n656_n7889.n70 0.1445
R1068 w_n656_n7889.n149 w_n656_n7889.n139 0.1445
R1069 w_n656_n7889.n344 w_n656_n7889.n139 0.1445
R1070 w_n656_n7889.n653 w_n656_n7889.n616 0.1445
R1071 w_n656_n7889.n479 w_n656_n7889.t5 0.142892
R1072 w_n656_n7889.t14 w_n656_n7889.n585 0.142892
R1073 w_n656_n7889.t11 w_n656_n7889.n405 0.13595
R1074 w_n656_n7889.n405 w_n656_n7889.t2 0.13595
R1075 w_n656_n7889.n478 w_n656_n7889.t2 0.13595
R1076 w_n656_n7889.t5 w_n656_n7889.n478 0.13595
R1077 w_n656_n7889.n519 w_n656_n7889.n518 0.1238
R1078 w_n656_n7889.n100 w_n656_n7889.n99 0.1238
R1079 w_n656_n7889.n526 w_n656_n7889.n525 0.1229
R1080 w_n656_n7889.n593 w_n656_n7889.n583 0.122
R1081 w_n656_n7889.n594 w_n656_n7889.n96 0.122
R1082 w_n656_n7889.n517 w_n656_n7889.n100 0.122
R1083 w_n656_n7889.n614 w_n656_n7889.n69 0.1211
R1084 w_n656_n7889.n520 w_n656_n7889.n519 0.1211
R1085 w_n656_n7889.n567 w_n656_n7889.n566 0.1211
R1086 w_n656_n7889.n535 w_n656_n7889.n131 0.1211
R1087 w_n656_n7889.n614 w_n656_n7889.n70 0.1211
R1088 w_n656_n7889.n345 w_n656_n7889.n344 0.1211
R1089 w_n656_n7889.n590 w_n656_n7889.n589 0.112022
R1090 w_n656_n7889.n322 w_n656_n7889.n309 0.102461
R1091 w_n656_n7889.n329 w_n656_n7889.n309 0.102461
R1092 w_n656_n7889.n604 w_n656_n7889.n603 0.102461
R1093 w_n656_n7889.n605 w_n656_n7889.n604 0.102461
R1094 w_n656_n7889.n331 w_n656_n7889.n330 0.102461
R1095 w_n656_n7889.n330 w_n656_n7889.n329 0.102461
R1096 w_n656_n7889.n506 w_n656_n7889.n355 0.0885435
R1097 w_n656_n7889.n345 w_n656_n7889.n104 0.0883705
R1098 w_n656_n7889.n582 w_n656_n7889.n581 0.0771667
R1099 w_n656_n7889.n582 w_n656_n7889.n97 0.0771667
R1100 w_n656_n7889.n580 w_n656_n7889.n579 0.0771667
R1101 w_n656_n7889.n579 w_n656_n7889.n578 0.0771667
R1102 w_n656_n7889.n52 w_n656_n7889.n50 0.0725
R1103 w_n656_n7889.n52 w_n656_n7889.n51 0.0725
R1104 w_n656_n7889.n48 w_n656_n7889.n47 0.0725
R1105 w_n656_n7889.n47 w_n656_n7889.n21 0.0725
R1106 w_n656_n7889.n473 w_n656_n7889.n398 0.0725
R1107 w_n656_n7889.n398 w_n656_n7889.n389 0.0725
R1108 w_n656_n7889.n404 w_n656_n7889.n401 0.0725
R1109 w_n656_n7889.n404 w_n656_n7889.n403 0.0725
R1110 w_n656_n7889.n481 w_n656_n7889.n397 0.0725
R1111 w_n656_n7889.n482 w_n656_n7889.n481 0.0725
R1112 w_n656_n7889.n477 w_n656_n7889.n475 0.0725
R1113 w_n656_n7889.n477 w_n656_n7889.n476 0.0725
R1114 w_n656_n7889.n407 w_n656_n7889.n406 0.0725
R1115 w_n656_n7889.n406 w_n656_n7889.n402 0.0725
R1116 w_n656_n7889.n54 w_n656_n7889.n25 0.0725
R1117 w_n656_n7889.n55 w_n656_n7889.n54 0.0725
R1118 w_n656_n7889.n618 w_n656_n7889.n615 0.0718661
R1119 w_n656_n7889.n68 w_n656_n7889.n15 0.0718661
R1120 w_n656_n7889.n655 w_n656_n7889.n6 0.0718661
R1121 w_n656_n7889.n537 w_n656_n7889.n536 0.0718661
R1122 w_n656_n7889.n534 w_n656_n7889.n533 0.0718661
R1123 w_n656_n7889.n565 w_n656_n7889.n103 0.0718661
R1124 w_n656_n7889.n565 w_n656_n7889.n564 0.0718661
R1125 w_n656_n7889.n342 w_n656_n7889.n341 0.0718661
R1126 w_n656_n7889.n527 w_n656_n7889.n526 0.0718661
R1127 w_n656_n7889.n123 w_n656_n7889.n72 0.0718661
R1128 w_n656_n7889.n543 w_n656_n7889.n73 0.0718661
R1129 w_n656_n7889.n112 w_n656_n7889.n74 0.0718661
R1130 w_n656_n7889.n536 w_n656_n7889.n130 0.0718661
R1131 w_n656_n7889.n534 w_n656_n7889.n532 0.0718661
R1132 w_n656_n7889.n341 w_n656_n7889.n340 0.0718661
R1133 w_n656_n7889.n528 w_n656_n7889.n527 0.0718661
R1134 w_n656_n7889.n542 w_n656_n7889.n72 0.0718661
R1135 w_n656_n7889.n111 w_n656_n7889.n73 0.0718661
R1136 w_n656_n7889.n75 w_n656_n7889.n74 0.0718661
R1137 w_n656_n7889.n639 w_n656_n7889.n615 0.0718661
R1138 w_n656_n7889.n640 w_n656_n7889.n68 0.0718661
R1139 w_n656_n7889.n656 w_n656_n7889.n655 0.0718661
R1140 w_n656_n7889.n592 w_n656_n7889.n591 0.0706471
R1141 w_n656_n7889.n581 w_n656_n7889.n98 0.0671667
R1142 w_n656_n7889.n98 w_n656_n7889.n97 0.0671667
R1143 w_n656_n7889.n580 w_n656_n7889.n577 0.0671667
R1144 w_n656_n7889.n578 w_n656_n7889.n577 0.0671667
R1145 w_n656_n7889.n654 w_n656_n7889.n614 0.066666
R1146 w_n656_n7889.n515 w_n656_n7889.n510 0.0649818
R1147 w_n656_n7889.n510 w_n656_n7889.n135 0.0640293
R1148 w_n656_n7889.n522 w_n656_n7889.n511 0.0564091
R1149 w_n656_n7889.n523 w_n656_n7889.n509 0.0550455
R1150 w_n656_n7889.n523 w_n656_n7889.n522 0.0536818
R1151 w_n656_n7889.n480 w_n656_n7889.n479 0.0513202
R1152 w_n656_n7889.n585 w_n656_n7889.n584 0.0513202
R1153 w_n656_n7889.n535 w_n656_n7889.n104 0.0504875
R1154 w_n656_n7889.n654 w_n656_n7889.n5 0.0491
R1155 w_n656_n7889.n654 w_n656_n7889.n653 0.0491
R1156 w_n656_n7889.n517 w_n656_n7889.n516 0.0375667
R1157 w_n656_n7889.n508 w_n656_n7889.n137 0.0345909
R1158 w_n656_n7889.n525 w_n656_n7889.n524 0.0336
R1159 w_n656_n7889.n138 w_n656_n7889.n137 0.0332273
R1160 w_n656_n7889.n505 w_n656_n7889.n504 0.0268241
R1161 w_n656_n7889.n67 w_n656_n7889.n65 0.0252233
R1162 w_n656_n7889.n450 w_n656_n7889.n71 0.0236225
R1163 w_n656_n7889.n614 w_n656_n7889.n71 0.0207767
R1164 w_n656_n7889.n520 w_n656_n7889.n511 0.0182266
R1165 w_n656_n7889.n450 w_n656_n7889.n449 0.0180156
R1166 w_n656_n7889.n449 w_n656_n7889.n440 0.0167742
R1167 w_n656_n7889.n654 w_n656_n7889.n67 0.01633
R1168 w_n656_n7889.n37 w_n656_n7889.n36 0.0161225
R1169 w_n656_n7889.n37 w_n656_n7889.n32 0.0151332
R1170 w_n656_n7889.n506 w_n656_n7889.n136 0.0148182
R1171 w_n656_n7889.n39 w_n656_n7889.n32 0.0147292
R1172 w_n656_n7889.n39 w_n656_n7889.n29 0.0147292
R1173 w_n656_n7889.n44 w_n656_n7889.n29 0.0147292
R1174 w_n656_n7889.n44 w_n656_n7889.n27 0.0147292
R1175 w_n656_n7889.n49 w_n656_n7889.n27 0.0147292
R1176 w_n656_n7889.n49 w_n656_n7889.n22 0.0147292
R1177 w_n656_n7889.n58 w_n656_n7889.n22 0.0147292
R1178 w_n656_n7889.n58 w_n656_n7889.n19 0.0147292
R1179 w_n656_n7889.n62 w_n656_n7889.n19 0.0147292
R1180 w_n656_n7889.n63 w_n656_n7889.n62 0.0147292
R1181 w_n656_n7889.n453 w_n656_n7889.n440 0.0147292
R1182 w_n656_n7889.n453 w_n656_n7889.n432 0.0147292
R1183 w_n656_n7889.n457 w_n656_n7889.n432 0.0147292
R1184 w_n656_n7889.n457 w_n656_n7889.n424 0.0147292
R1185 w_n656_n7889.n461 w_n656_n7889.n424 0.0147292
R1186 w_n656_n7889.n461 w_n656_n7889.n416 0.0147292
R1187 w_n656_n7889.n465 w_n656_n7889.n416 0.0147292
R1188 w_n656_n7889.n465 w_n656_n7889.n409 0.0147292
R1189 w_n656_n7889.n470 w_n656_n7889.n409 0.0147292
R1190 w_n656_n7889.n470 w_n656_n7889.n400 0.0147292
R1191 w_n656_n7889.n474 w_n656_n7889.n400 0.0147292
R1192 w_n656_n7889.n474 w_n656_n7889.n390 0.0147292
R1193 w_n656_n7889.n484 w_n656_n7889.n390 0.0147292
R1194 w_n656_n7889.n484 w_n656_n7889.n382 0.0147292
R1195 w_n656_n7889.n488 w_n656_n7889.n382 0.0147292
R1196 w_n656_n7889.n488 w_n656_n7889.n374 0.0147292
R1197 w_n656_n7889.n492 w_n656_n7889.n374 0.0147292
R1198 w_n656_n7889.n492 w_n656_n7889.n366 0.0147292
R1199 w_n656_n7889.n497 w_n656_n7889.n366 0.0147292
R1200 w_n656_n7889.n497 w_n656_n7889.n361 0.0147292
R1201 w_n656_n7889.n501 w_n656_n7889.n361 0.0147292
R1202 w_n656_n7889.n502 w_n656_n7889.n501 0.0147292
R1203 w_n656_n7889.n516 w_n656_n7889.n515 0.0086
R1204 w_n656_n7889.n65 w_n656_n7889.n16 0.00821544
R1205 w_n656_n7889.n504 w_n656_n7889.n356 0.00821544
R1206 w_n656_n7889.n502 w_n656_n7889.n356 0.0079917
R1207 w_n656_n7889.n63 w_n656_n7889.n16 0.0079917
R1208 w_n656_n7889.n524 w_n656_n7889.n135 0.0077
R1209 w_n656_n7889.n521 w_n656_n7889.n520 0.00612271
R1210 w_n656_n7889.n606 w_n656_n7889.n605 0.00559075
R1211 w_n656_n7889.t8 w_n656_n7889.n480 0.00454485
R1212 w_n656_n7889.n586 w_n656_n7889.t14 0.00454485
R1213 w_n656_n7889.n518 w_n656_n7889.n98 0.0032
R1214 w_n656_n7889.n136 w_n656_n7889.n133 0.00307783
R1215 w_n656_n7889.n583 w_n656_n7889.n582 0.0023
R1216 w_n656_n7889.n579 w_n656_n7889.n96 0.0023
R1217 w_n656_n7889.n576 w_n656_n7889.n99 0.0023
R1218 w_n656_n7889.n345 w_n656_n7889.n133 0.00206912
R1219 w_n656_n7889.n522 w_n656_n7889.n521 0.00185378
R1220 w_n656_n7889.n577 w_n656_n7889.n576 0.0014
R1221 w_n656_n7889.n521 w_n656_n7889.n134 0.00100639
R1222 w_n656_n7889.n506 w_n656_n7889.n505 0.000588933
C0 w_n656_n7889.n0 VSUBS 0.06317f
C1 w_n656_n7889.n1 VSUBS 0.00799f
C2 w_n656_n7889.n2 VSUBS 0.00799f
C3 w_n656_n7889.n3 VSUBS 0.00637f
C4 w_n656_n7889.t31 VSUBS 0.00965f
C5 w_n656_n7889.t33 VSUBS 0.0786f
C6 w_n656_n7889.n4 VSUBS 0.03458f
C7 w_n656_n7889.n5 VSUBS 0.00121f
C8 w_n656_n7889.n6 VSUBS 0.00181f
C9 w_n656_n7889.n7 VSUBS 0.0013f
C10 w_n656_n7889.n8 VSUBS 0.05809f
C11 w_n656_n7889.t32 VSUBS 0.02905f
C12 w_n656_n7889.n9 VSUBS 0.0013f
C13 w_n656_n7889.n10 VSUBS 0.00181f
C14 w_n656_n7889.n11 VSUBS 0.00181f
C15 w_n656_n7889.n12 VSUBS 0.00181f
C16 w_n656_n7889.n13 VSUBS 0.0013f
C17 w_n656_n7889.t26 VSUBS 0.02905f
C18 w_n656_n7889.n14 VSUBS 0.0013f
C19 w_n656_n7889.n15 VSUBS 0.00181f
C20 w_n656_n7889.n16 VSUBS 0
C21 w_n656_n7889.n17 VSUBS 0.00252f
C22 w_n656_n7889.n18 VSUBS 0.00181f
C23 w_n656_n7889.n19 VSUBS 0.01827f
C24 w_n656_n7889.n20 VSUBS 0.00181f
C25 w_n656_n7889.n21 VSUBS 0.00135f
C26 w_n656_n7889.n22 VSUBS 0.01827f
C27 w_n656_n7889.n23 VSUBS 0.00181f
C28 w_n656_n7889.n24 VSUBS 0.00181f
C29 w_n656_n7889.n25 VSUBS 0.00135f
C30 w_n656_n7889.t30 VSUBS 0.0306f
C31 w_n656_n7889.n26 VSUBS 0.00181f
C32 w_n656_n7889.n27 VSUBS 0.01827f
C33 w_n656_n7889.n28 VSUBS 0.00181f
C34 w_n656_n7889.n29 VSUBS 0.01827f
C35 w_n656_n7889.n30 VSUBS 0.00181f
C36 w_n656_n7889.n31 VSUBS 0.00736f
C37 w_n656_n7889.n32 VSUBS 0.02797f
C38 w_n656_n7889.n33 VSUBS 0.00181f
C39 w_n656_n7889.n34 VSUBS 0.00181f
C40 w_n656_n7889.n35 VSUBS 0.00483f
C41 w_n656_n7889.n36 VSUBS 0.05028f
C42 w_n656_n7889.n37 VSUBS 0
C43 w_n656_n7889.n38 VSUBS 0.00635f
C44 w_n656_n7889.n39 VSUBS 0.01827f
C45 w_n656_n7889.n40 VSUBS 0.00181f
C46 w_n656_n7889.n41 VSUBS 0.00181f
C47 w_n656_n7889.n42 VSUBS 0.00181f
C48 w_n656_n7889.n43 VSUBS 0.00181f
C49 w_n656_n7889.n44 VSUBS 0.01827f
C50 w_n656_n7889.n45 VSUBS 0.00181f
C51 w_n656_n7889.n46 VSUBS 0.00181f
C52 w_n656_n7889.n47 VSUBS 0.01386f
C53 w_n656_n7889.n48 VSUBS 0.00135f
C54 w_n656_n7889.n49 VSUBS 0.01827f
C55 w_n656_n7889.n50 VSUBS 0.00135f
C56 w_n656_n7889.n51 VSUBS 0.00135f
C57 w_n656_n7889.n52 VSUBS 0.01386f
C58 w_n656_n7889.t27 VSUBS 0.0306f
C59 w_n656_n7889.n53 VSUBS 0.01941f
C60 w_n656_n7889.n54 VSUBS 0
C61 w_n656_n7889.n55 VSUBS 0.00135f
C62 w_n656_n7889.n56 VSUBS 0.00181f
C63 w_n656_n7889.n57 VSUBS 0.00181f
C64 w_n656_n7889.n58 VSUBS 0.01827f
C65 w_n656_n7889.n59 VSUBS 0.00181f
C66 w_n656_n7889.n60 VSUBS 0.00181f
C67 w_n656_n7889.n61 VSUBS 0.00418f
C68 w_n656_n7889.n62 VSUBS 0.01827f
C69 w_n656_n7889.n63 VSUBS 0.01827f
C70 w_n656_n7889.n64 VSUBS 0.00252f
C71 w_n656_n7889.n65 VSUBS 0.02507f
C72 w_n656_n7889.t28 VSUBS 0.00976f
C73 w_n656_n7889.t25 VSUBS 0.00976f
C74 w_n656_n7889.n66 VSUBS 0.01013f
C75 w_n656_n7889.n67 VSUBS 0.02675f
C76 w_n656_n7889.n69 VSUBS 0.00166f
C77 w_n656_n7889.n70 VSUBS 0.00166f
C78 w_n656_n7889.n71 VSUBS 0.02878f
C79 w_n656_n7889.n75 VSUBS 0.00181f
C80 w_n656_n7889.n76 VSUBS 0.0013f
C81 w_n656_n7889.n77 VSUBS 0.0013f
C82 w_n656_n7889.n78 VSUBS 0.0013f
C83 w_n656_n7889.n79 VSUBS 0.00147f
C84 w_n656_n7889.n80 VSUBS 0.01399f
C85 w_n656_n7889.n81 VSUBS 0.00653f
C86 w_n656_n7889.n82 VSUBS 0.01759f
C87 w_n656_n7889.n83 VSUBS 0.17997f
C88 w_n656_n7889.n84 VSUBS 2.2336f
C89 w_n656_n7889.n85 VSUBS 0.53282f
C90 w_n656_n7889.n86 VSUBS 0.19698f
C91 w_n656_n7889.n87 VSUBS 0.01203f
C92 w_n656_n7889.n88 VSUBS 0.01203f
C93 w_n656_n7889.n89 VSUBS 0.00891f
C94 w_n656_n7889.t18 VSUBS 0.01911f
C95 w_n656_n7889.t19 VSUBS 0.182f
C96 w_n656_n7889.n90 VSUBS 0.04136f
C97 w_n656_n7889.n91 VSUBS 0.00181f
C98 w_n656_n7889.n92 VSUBS 0.00181f
C99 w_n656_n7889.n93 VSUBS 0.0013f
C100 w_n656_n7889.n94 VSUBS 0.11337f
C101 w_n656_n7889.n95 VSUBS 0.0013f
C102 w_n656_n7889.n96 VSUBS 0
C103 w_n656_n7889.n97 VSUBS 0
C104 w_n656_n7889.n98 VSUBS 0
C105 w_n656_n7889.n99 VSUBS 0
C106 w_n656_n7889.n100 VSUBS 0.00153f
C107 w_n656_n7889.n101 VSUBS 0.11974f
C108 w_n656_n7889.n102 VSUBS 0.0013f
C109 w_n656_n7889.n103 VSUBS 0.00181f
C110 w_n656_n7889.n104 VSUBS 0.06995f
C111 w_n656_n7889.n105 VSUBS 0.00181f
C112 w_n656_n7889.n106 VSUBS 0.0013f
C113 w_n656_n7889.n107 VSUBS 0.11337f
C114 w_n656_n7889.n108 VSUBS 0.01559f
C115 w_n656_n7889.n109 VSUBS 0.0013f
C116 w_n656_n7889.n110 VSUBS 0.0013f
C117 w_n656_n7889.n111 VSUBS 0.00181f
C118 w_n656_n7889.n112 VSUBS 0.00181f
C119 w_n656_n7889.t4 VSUBS 0.11337f
C120 w_n656_n7889.n113 VSUBS 0.00143f
C121 w_n656_n7889.n114 VSUBS 0.0013f
C122 w_n656_n7889.n115 VSUBS 0.00181f
C123 w_n656_n7889.n116 VSUBS 0.00181f
C124 w_n656_n7889.n117 VSUBS 0.00181f
C125 w_n656_n7889.n118 VSUBS 0.0013f
C126 w_n656_n7889.n119 VSUBS 0.12895f
C127 w_n656_n7889.n120 VSUBS 0.0013f
C128 w_n656_n7889.t1 VSUBS 0.11337f
C129 w_n656_n7889.n121 VSUBS 0.0013f
C130 w_n656_n7889.n122 VSUBS 0.0013f
C131 w_n656_n7889.n123 VSUBS 0.00181f
C132 w_n656_n7889.n124 VSUBS 0.22673f
C133 w_n656_n7889.n125 VSUBS 0.0013f
C134 w_n656_n7889.n126 VSUBS 0.0013f
C135 w_n656_n7889.t10 VSUBS 0.11337f
C136 w_n656_n7889.n127 VSUBS 0.0013f
C137 w_n656_n7889.n128 VSUBS 0.0013f
C138 w_n656_n7889.n129 VSUBS 0.00181f
C139 w_n656_n7889.n130 VSUBS 0.00181f
C140 w_n656_n7889.n131 VSUBS 0.00166f
C141 w_n656_n7889.n132 VSUBS 0.00181f
C142 w_n656_n7889.n133 VSUBS 0.00168f
C143 w_n656_n7889.n134 VSUBS 0
C144 w_n656_n7889.n135 VSUBS 0
C145 w_n656_n7889.n136 VSUBS 0.00376f
C146 w_n656_n7889.n137 VSUBS 0
C147 w_n656_n7889.n138 VSUBS 0
C148 w_n656_n7889.n139 VSUBS 0.00181f
C149 w_n656_n7889.n140 VSUBS 0.00181f
C150 w_n656_n7889.n141 VSUBS 0.01203f
C151 w_n656_n7889.t16 VSUBS 0.11337f
C152 w_n656_n7889.n142 VSUBS 0.0013f
C153 w_n656_n7889.n143 VSUBS 0.0013f
C154 w_n656_n7889.n144 VSUBS 0.01203f
C155 w_n656_n7889.n145 VSUBS 0.00147f
C156 w_n656_n7889.n146 VSUBS 0.00181f
C157 w_n656_n7889.t15 VSUBS 0.01911f
C158 w_n656_n7889.t17 VSUBS 0.182f
C159 w_n656_n7889.n147 VSUBS 0.04136f
C160 w_n656_n7889.n148 VSUBS 0.00147f
C161 w_n656_n7889.n149 VSUBS 0.00426f
C162 w_n656_n7889.n150 VSUBS 0.01958f
C163 w_n656_n7889.n151 VSUBS 0.24657f
C164 w_n656_n7889.n152 VSUBS 0.00866f
C165 w_n656_n7889.n153 VSUBS 0.00512f
C166 w_n656_n7889.n154 VSUBS 0.00512f
C167 w_n656_n7889.n155 VSUBS 0.00504f
C168 w_n656_n7889.n156 VSUBS 0.00401f
C169 w_n656_n7889.n157 VSUBS 0.02353f
C170 w_n656_n7889.n158 VSUBS 0.02416f
C171 w_n656_n7889.n159 VSUBS 0.00181f
C172 w_n656_n7889.n160 VSUBS 0.00181f
C173 w_n656_n7889.n161 VSUBS 0.0013f
C174 w_n656_n7889.n162 VSUBS -1.00894f
C175 w_n656_n7889.n163 VSUBS 0.0013f
C176 w_n656_n7889.n164 VSUBS 0.11337f
C177 w_n656_n7889.n165 VSUBS 0.0013f
C178 w_n656_n7889.n166 VSUBS 0.0013f
C179 w_n656_n7889.n167 VSUBS 0.00181f
C180 w_n656_n7889.n168 VSUBS 0.00181f
C181 w_n656_n7889.n169 VSUBS 0.00181f
C182 w_n656_n7889.n170 VSUBS 0.0013f
C183 w_n656_n7889.n171 VSUBS 0.22673f
C184 w_n656_n7889.n172 VSUBS 0.0013f
C185 w_n656_n7889.n173 VSUBS 0.0013f
C186 w_n656_n7889.n174 VSUBS 0.0013f
C187 w_n656_n7889.n175 VSUBS 0.0013f
C188 w_n656_n7889.n176 VSUBS 0.00181f
C189 w_n656_n7889.n177 VSUBS 0.00181f
C190 w_n656_n7889.n178 VSUBS 0.00181f
C191 w_n656_n7889.n179 VSUBS 0.00181f
C192 w_n656_n7889.n180 VSUBS 0.00401f
C193 w_n656_n7889.n181 VSUBS 0.02353f
C194 w_n656_n7889.n182 VSUBS 0.02416f
C195 w_n656_n7889.n183 VSUBS 0.00181f
C196 w_n656_n7889.n184 VSUBS 0.00181f
C197 w_n656_n7889.n185 VSUBS 0.00181f
C198 w_n656_n7889.n186 VSUBS 0.00181f
C199 w_n656_n7889.n187 VSUBS 0.0013f
C200 w_n656_n7889.n188 VSUBS 0.22673f
C201 w_n656_n7889.n189 VSUBS 0.0013f
C202 w_n656_n7889.n190 VSUBS 0.0013f
C203 w_n656_n7889.n191 VSUBS 0.0013f
C204 w_n656_n7889.n192 VSUBS 0.00181f
C205 w_n656_n7889.n193 VSUBS 0.00181f
C206 w_n656_n7889.n194 VSUBS 0.00181f
C207 w_n656_n7889.n195 VSUBS 0.0013f
C208 w_n656_n7889.n196 VSUBS 0.16863f
C209 w_n656_n7889.n197 VSUBS 0.0013f
C210 w_n656_n7889.n198 VSUBS 0.0013f
C211 w_n656_n7889.n199 VSUBS 0.0013f
C212 w_n656_n7889.n200 VSUBS 0.0013f
C213 w_n656_n7889.n201 VSUBS 0.00181f
C214 w_n656_n7889.n202 VSUBS 0.01123f
C215 w_n656_n7889.n203 VSUBS 0.00866f
C216 w_n656_n7889.n204 VSUBS 1.02739f
C217 w_n656_n7889.n205 VSUBS 0.00512f
C218 w_n656_n7889.n206 VSUBS 0.0013f
C219 w_n656_n7889.n207 VSUBS 0.00401f
C220 w_n656_n7889.n208 VSUBS 0.02353f
C221 w_n656_n7889.n209 VSUBS 0.02416f
C222 w_n656_n7889.n210 VSUBS 0.00946f
C223 w_n656_n7889.n211 VSUBS 0.00439f
C224 w_n656_n7889.n212 VSUBS 0.00181f
C225 w_n656_n7889.n213 VSUBS 0.00181f
C226 w_n656_n7889.n214 VSUBS 0.00181f
C227 w_n656_n7889.n215 VSUBS 0.00181f
C228 w_n656_n7889.n216 VSUBS 0.00181f
C229 w_n656_n7889.n217 VSUBS 0.00181f
C230 w_n656_n7889.n218 VSUBS 0.00147f
C231 w_n656_n7889.n219 VSUBS 0.00512f
C232 w_n656_n7889.n220 VSUBS 0.11337f
C233 w_n656_n7889.n221 VSUBS 0.00866f
C234 w_n656_n7889.n222 VSUBS 0.00181f
C235 w_n656_n7889.n223 VSUBS 0.0013f
C236 w_n656_n7889.n224 VSUBS 0.00181f
C237 w_n656_n7889.n225 VSUBS 0.00181f
C238 w_n656_n7889.n226 VSUBS 0.00181f
C239 w_n656_n7889.n227 VSUBS 0.00181f
C240 w_n656_n7889.n228 VSUBS 0.00181f
C241 w_n656_n7889.n229 VSUBS 0.00181f
C242 w_n656_n7889.n230 VSUBS 0.00181f
C243 w_n656_n7889.n231 VSUBS 0.0013f
C244 w_n656_n7889.n232 VSUBS 0.00181f
C245 w_n656_n7889.n233 VSUBS 0.00181f
C246 w_n656_n7889.n234 VSUBS 0.0013f
C247 w_n656_n7889.n235 VSUBS 0.00181f
C248 w_n656_n7889.n236 VSUBS 0.00181f
C249 w_n656_n7889.n237 VSUBS 0.00181f
C250 w_n656_n7889.n238 VSUBS 0.00147f
C251 w_n656_n7889.n239 VSUBS 0.00439f
C252 w_n656_n7889.n240 VSUBS 0.00401f
C253 w_n656_n7889.n241 VSUBS 0.02353f
C254 w_n656_n7889.n242 VSUBS 0.02416f
C255 w_n656_n7889.n243 VSUBS 0.00946f
C256 w_n656_n7889.n244 VSUBS 0.01123f
C257 w_n656_n7889.n245 VSUBS 0.00504f
C258 w_n656_n7889.n246 VSUBS 0.00147f
C259 w_n656_n7889.n247 VSUBS 0.00512f
C260 w_n656_n7889.n248 VSUBS 0.24657f
C261 w_n656_n7889.n249 VSUBS 0.00512f
C262 w_n656_n7889.n250 VSUBS 0.00147f
C263 w_n656_n7889.n251 VSUBS 0.00504f
C264 w_n656_n7889.n252 VSUBS 0.00181f
C265 w_n656_n7889.n253 VSUBS 0.00181f
C266 w_n656_n7889.n254 VSUBS 0.00181f
C267 w_n656_n7889.n255 VSUBS 0.00181f
C268 w_n656_n7889.n256 VSUBS 0.00181f
C269 w_n656_n7889.n257 VSUBS 0.00181f
C270 w_n656_n7889.n258 VSUBS 0.00181f
C271 w_n656_n7889.n259 VSUBS 0.00181f
C272 w_n656_n7889.n260 VSUBS 0.0013f
C273 w_n656_n7889.n261 VSUBS 0.22673f
C274 w_n656_n7889.n262 VSUBS 0.0013f
C275 w_n656_n7889.n263 VSUBS 0.00181f
C276 w_n656_n7889.n264 VSUBS 0.00181f
C277 w_n656_n7889.n265 VSUBS 0.00181f
C278 w_n656_n7889.n266 VSUBS 0.00181f
C279 w_n656_n7889.n267 VSUBS 0.00181f
C280 w_n656_n7889.n268 VSUBS 0.0013f
C281 w_n656_n7889.n269 VSUBS 0.22673f
C282 w_n656_n7889.n270 VSUBS 0.0013f
C283 w_n656_n7889.n271 VSUBS 0.0013f
C284 w_n656_n7889.n272 VSUBS 0.00181f
C285 w_n656_n7889.n273 VSUBS 0.00181f
C286 w_n656_n7889.n274 VSUBS 0.00181f
C287 w_n656_n7889.n275 VSUBS 0.00181f
C288 w_n656_n7889.n276 VSUBS 0.0013f
C289 w_n656_n7889.n277 VSUBS 0.00181f
C290 w_n656_n7889.n278 VSUBS 0.00181f
C291 w_n656_n7889.n279 VSUBS 0.00512f
C292 w_n656_n7889.n280 VSUBS 0.00147f
C293 w_n656_n7889.n281 VSUBS 0.00439f
C294 w_n656_n7889.n282 VSUBS 0.00946f
C295 w_n656_n7889.n283 VSUBS 0.01123f
C296 w_n656_n7889.n284 VSUBS 0.00504f
C297 w_n656_n7889.n285 VSUBS 0.00512f
C298 w_n656_n7889.n286 VSUBS 0.00147f
C299 w_n656_n7889.n287 VSUBS 0.00181f
C300 w_n656_n7889.n288 VSUBS 0.00181f
C301 w_n656_n7889.n289 VSUBS 0.00181f
C302 w_n656_n7889.n290 VSUBS 0.0013f
C303 w_n656_n7889.n291 VSUBS 0.22673f
C304 w_n656_n7889.n292 VSUBS 0.0013f
C305 w_n656_n7889.n293 VSUBS 0.00181f
C306 w_n656_n7889.n294 VSUBS 0.00181f
C307 w_n656_n7889.n295 VSUBS 0.00181f
C308 w_n656_n7889.n296 VSUBS 0.00181f
C309 w_n656_n7889.n297 VSUBS 0.00147f
C310 w_n656_n7889.n298 VSUBS 0.00181f
C311 w_n656_n7889.n299 VSUBS 0.0013f
C312 w_n656_n7889.n300 VSUBS -0.04943f
C313 w_n656_n7889.n301 VSUBS 0.0013f
C314 w_n656_n7889.n302 VSUBS 0.00181f
C315 w_n656_n7889.n303 VSUBS 0.00147f
C316 w_n656_n7889.n304 VSUBS 0.00439f
C317 w_n656_n7889.n305 VSUBS 0.00946f
C318 w_n656_n7889.n306 VSUBS 0.01123f
C319 w_n656_n7889.n307 VSUBS 0.00866f
C320 w_n656_n7889.n308 VSUBS 1.11241f
C321 w_n656_n7889.n309 VSUBS 0.02228f
C322 w_n656_n7889.n310 VSUBS 0.01203f
C323 w_n656_n7889.n311 VSUBS 0.00181f
C324 w_n656_n7889.n312 VSUBS 0.00181f
C325 w_n656_n7889.n313 VSUBS 0.00181f
C326 w_n656_n7889.n314 VSUBS 0.00181f
C327 w_n656_n7889.n315 VSUBS 0.0013f
C328 w_n656_n7889.n316 VSUBS 0.00181f
C329 w_n656_n7889.n317 VSUBS 0.00181f
C330 w_n656_n7889.n318 VSUBS 0.00147f
C331 w_n656_n7889.n319 VSUBS 0.00426f
C332 w_n656_n7889.t20 VSUBS 0.01911f
C333 w_n656_n7889.t21 VSUBS 0.182f
C334 w_n656_n7889.n320 VSUBS 0.04136f
C335 w_n656_n7889.n321 VSUBS 0.01958f
C336 w_n656_n7889.n322 VSUBS 0.03368f
C337 w_n656_n7889.n323 VSUBS 0.00891f
C338 w_n656_n7889.n324 VSUBS 0.00181f
C339 w_n656_n7889.n325 VSUBS 0.00181f
C340 w_n656_n7889.n326 VSUBS 0.00147f
C341 w_n656_n7889.n327 VSUBS 0.01203f
C342 w_n656_n7889.n328 VSUBS 0.24657f
C343 w_n656_n7889.n329 VSUBS 1.10391f
C344 w_n656_n7889.n330 VSUBS 0.02228f
C345 w_n656_n7889.n331 VSUBS 0.03368f
C346 w_n656_n7889.n332 VSUBS 0.00891f
C347 w_n656_n7889.n333 VSUBS 0.00181f
C348 w_n656_n7889.n334 VSUBS 0.00181f
C349 w_n656_n7889.n335 VSUBS 0.0013f
C350 w_n656_n7889.n336 VSUBS 0.16013f
C351 w_n656_n7889.n337 VSUBS 0.0013f
C352 w_n656_n7889.n338 VSUBS 0.0013f
C353 w_n656_n7889.n339 VSUBS 0.0013f
C354 w_n656_n7889.n340 VSUBS 0.00181f
C355 w_n656_n7889.n342 VSUBS 0.00181f
C356 w_n656_n7889.n343 VSUBS 0.00181f
C357 w_n656_n7889.n344 VSUBS 0.00166f
C358 w_n656_n7889.n345 VSUBS 0.03974f
C359 w_n656_n7889.t9 VSUBS 0.0192f
C360 w_n656_n7889.n346 VSUBS 0.00909f
C361 w_n656_n7889.n347 VSUBS 0.00202f
C362 w_n656_n7889.t0 VSUBS 0.019f
C363 w_n656_n7889.n348 VSUBS 0.00757f
C364 w_n656_n7889.t3 VSUBS 0.019f
C365 w_n656_n7889.t6 VSUBS 0.01915f
C366 w_n656_n7889.n349 VSUBS 0.01472f
C367 w_n656_n7889.n350 VSUBS 0.01783f
C368 w_n656_n7889.n351 VSUBS 0
C369 w_n656_n7889.n352 VSUBS 0.00755f
C370 w_n656_n7889.n353 VSUBS 0.0015f
C371 w_n656_n7889.n354 VSUBS 0.0015f
C372 w_n656_n7889.n355 VSUBS 0.00125f
C373 w_n656_n7889.n356 VSUBS 0
C374 w_n656_n7889.n357 VSUBS 0.00212f
C375 w_n656_n7889.n358 VSUBS 0.00212f
C376 w_n656_n7889.n359 VSUBS 0.00212f
C377 w_n656_n7889.n360 VSUBS 0.00181f
C378 w_n656_n7889.n361 VSUBS 0.01827f
C379 w_n656_n7889.n362 VSUBS 0.00181f
C380 w_n656_n7889.n363 VSUBS 0.00181f
C381 w_n656_n7889.n364 VSUBS 0.0038f
C382 w_n656_n7889.n365 VSUBS 0.00181f
C383 w_n656_n7889.n366 VSUBS 0.01827f
C384 w_n656_n7889.n367 VSUBS 0.00181f
C385 w_n656_n7889.n368 VSUBS 0.00181f
C386 w_n656_n7889.n369 VSUBS 0.00181f
C387 w_n656_n7889.n370 VSUBS 0.00181f
C388 w_n656_n7889.n371 VSUBS 0.00181f
C389 w_n656_n7889.n372 VSUBS 0.00181f
C390 w_n656_n7889.n373 VSUBS 0.00181f
C391 w_n656_n7889.n374 VSUBS 0.01827f
C392 w_n656_n7889.n375 VSUBS 0.00181f
C393 w_n656_n7889.n376 VSUBS 0.00181f
C394 w_n656_n7889.n377 VSUBS 0.00181f
C395 w_n656_n7889.n378 VSUBS 0.00181f
C396 w_n656_n7889.n379 VSUBS 0.00181f
C397 w_n656_n7889.n380 VSUBS 0.00181f
C398 w_n656_n7889.n381 VSUBS 0.00181f
C399 w_n656_n7889.n382 VSUBS 0.01827f
C400 w_n656_n7889.n383 VSUBS 0.00181f
C401 w_n656_n7889.n384 VSUBS 0.00181f
C402 w_n656_n7889.n385 VSUBS 0.00181f
C403 w_n656_n7889.n386 VSUBS 0.00181f
C404 w_n656_n7889.n387 VSUBS 0.00181f
C405 w_n656_n7889.n388 VSUBS 0.00181f
C406 w_n656_n7889.n389 VSUBS 0.00135f
C407 w_n656_n7889.n390 VSUBS 0.01827f
C408 w_n656_n7889.n391 VSUBS 0.00181f
C409 w_n656_n7889.n392 VSUBS 0.00181f
C410 w_n656_n7889.n393 VSUBS 0.00181f
C411 w_n656_n7889.n394 VSUBS 0.00181f
C412 w_n656_n7889.n395 VSUBS 0.00181f
C413 w_n656_n7889.n396 VSUBS 0.00181f
C414 w_n656_n7889.n397 VSUBS 0.00135f
C415 w_n656_n7889.n398 VSUBS 0.00143f
C416 w_n656_n7889.t2 VSUBS 0.03881f
C417 w_n656_n7889.n399 VSUBS 0.00181f
C418 w_n656_n7889.n400 VSUBS 0.01827f
C419 w_n656_n7889.n401 VSUBS 0.00135f
C420 w_n656_n7889.n402 VSUBS 0.00135f
C421 w_n656_n7889.n403 VSUBS 0.00135f
C422 w_n656_n7889.n404 VSUBS 0
C423 w_n656_n7889.n405 VSUBS 0.03881f
C424 w_n656_n7889.t11 VSUBS 0.06448f
C425 w_n656_n7889.n406 VSUBS 0.02353f
C426 w_n656_n7889.n407 VSUBS 0.00135f
C427 w_n656_n7889.n408 VSUBS 0.00181f
C428 w_n656_n7889.n409 VSUBS 0.01827f
C429 w_n656_n7889.n410 VSUBS 0.00181f
C430 w_n656_n7889.n411 VSUBS 0.00181f
C431 w_n656_n7889.n412 VSUBS 0.00181f
C432 w_n656_n7889.n413 VSUBS 0.00181f
C433 w_n656_n7889.n414 VSUBS 0.00181f
C434 w_n656_n7889.n415 VSUBS 0.00181f
C435 w_n656_n7889.n416 VSUBS 0.01827f
C436 w_n656_n7889.n417 VSUBS 0.00181f
C437 w_n656_n7889.n418 VSUBS 0.00181f
C438 w_n656_n7889.n419 VSUBS 0.00181f
C439 w_n656_n7889.n420 VSUBS 0.00181f
C440 w_n656_n7889.n421 VSUBS 0.00181f
C441 w_n656_n7889.n422 VSUBS 0.00181f
C442 w_n656_n7889.n423 VSUBS 0.00181f
C443 w_n656_n7889.n424 VSUBS 0.01827f
C444 w_n656_n7889.n425 VSUBS 0.00181f
C445 w_n656_n7889.n426 VSUBS 0.00181f
C446 w_n656_n7889.n427 VSUBS 0.00181f
C447 w_n656_n7889.n428 VSUBS 0.00181f
C448 w_n656_n7889.n429 VSUBS 0.00181f
C449 w_n656_n7889.n430 VSUBS 0.00181f
C450 w_n656_n7889.n431 VSUBS 0.00181f
C451 w_n656_n7889.n432 VSUBS 0.01827f
C452 w_n656_n7889.n433 VSUBS 0.00181f
C453 w_n656_n7889.n434 VSUBS 0.00181f
C454 w_n656_n7889.n435 VSUBS 0.00181f
C455 w_n656_n7889.n436 VSUBS 0.00181f
C456 w_n656_n7889.n437 VSUBS 0.00181f
C457 w_n656_n7889.n438 VSUBS 0.00181f
C458 w_n656_n7889.n439 VSUBS 0.00763f
C459 w_n656_n7889.n440 VSUBS 0.03026f
C460 w_n656_n7889.n441 VSUBS 0.00763f
C461 w_n656_n7889.n442 VSUBS 0.00181f
C462 w_n656_n7889.n443 VSUBS 0.00181f
C463 w_n656_n7889.n444 VSUBS 0.00181f
C464 w_n656_n7889.n445 VSUBS 0.00181f
C465 w_n656_n7889.n446 VSUBS 0.00181f
C466 w_n656_n7889.n447 VSUBS 0.00671f
C467 w_n656_n7889.n448 VSUBS 0.00521f
C468 w_n656_n7889.n449 VSUBS 0
C469 w_n656_n7889.n450 VSUBS 0.03652f
C470 w_n656_n7889.n451 VSUBS 0.00521f
C471 w_n656_n7889.n452 VSUBS 0.00181f
C472 w_n656_n7889.n453 VSUBS 0.01827f
C473 w_n656_n7889.n454 VSUBS 0.00181f
C474 w_n656_n7889.n455 VSUBS 0.00181f
C475 w_n656_n7889.n456 VSUBS 0.00181f
C476 w_n656_n7889.n457 VSUBS 0.01827f
C477 w_n656_n7889.n458 VSUBS 0.00181f
C478 w_n656_n7889.n459 VSUBS 0.00181f
C479 w_n656_n7889.n460 VSUBS 0.00181f
C480 w_n656_n7889.n461 VSUBS 0.01827f
C481 w_n656_n7889.n462 VSUBS 0.00181f
C482 w_n656_n7889.n463 VSUBS 0.00181f
C483 w_n656_n7889.n464 VSUBS 0.00181f
C484 w_n656_n7889.n465 VSUBS 0.01827f
C485 w_n656_n7889.n466 VSUBS 0.00181f
C486 w_n656_n7889.n467 VSUBS 0.00181f
C487 w_n656_n7889.n468 VSUBS 0.00181f
C488 w_n656_n7889.n469 VSUBS 0.00181f
C489 w_n656_n7889.n470 VSUBS 0.01827f
C490 w_n656_n7889.n471 VSUBS 0.00181f
C491 w_n656_n7889.n472 VSUBS 0.00181f
C492 w_n656_n7889.n473 VSUBS 0.00135f
C493 w_n656_n7889.n474 VSUBS 0.01827f
C494 w_n656_n7889.n475 VSUBS 0.00135f
C495 w_n656_n7889.n476 VSUBS 0.00135f
C496 w_n656_n7889.n477 VSUBS 0
C497 w_n656_n7889.n478 VSUBS 0.03881f
C498 w_n656_n7889.t5 VSUBS 0.04119f
C499 w_n656_n7889.n479 VSUBS 0.02273f
C500 w_n656_n7889.n480 VSUBS 0.01484f
C501 w_n656_n7889.t8 VSUBS 0.03723f
C502 w_n656_n7889.n481 VSUBS 0.02723f
C503 w_n656_n7889.n482 VSUBS 0.00135f
C504 w_n656_n7889.n483 VSUBS 0.00181f
C505 w_n656_n7889.n484 VSUBS 0.01827f
C506 w_n656_n7889.n485 VSUBS 0.00181f
C507 w_n656_n7889.n486 VSUBS 0.00181f
C508 w_n656_n7889.n487 VSUBS 0.00181f
C509 w_n656_n7889.n488 VSUBS 0.01827f
C510 w_n656_n7889.n489 VSUBS 0.00181f
C511 w_n656_n7889.n490 VSUBS 0.00181f
C512 w_n656_n7889.n491 VSUBS 0.00181f
C513 w_n656_n7889.n492 VSUBS 0.01827f
C514 w_n656_n7889.n493 VSUBS 0.00181f
C515 w_n656_n7889.n494 VSUBS 0.00181f
C516 w_n656_n7889.n495 VSUBS 0.00181f
C517 w_n656_n7889.n496 VSUBS 0.00181f
C518 w_n656_n7889.n497 VSUBS 0.01827f
C519 w_n656_n7889.n498 VSUBS 0.00181f
C520 w_n656_n7889.n499 VSUBS 0.00181f
C521 w_n656_n7889.n500 VSUBS 0.00181f
C522 w_n656_n7889.n501 VSUBS 0.01827f
C523 w_n656_n7889.n502 VSUBS 0.01827f
C524 w_n656_n7889.n503 VSUBS 0.00212f
C525 w_n656_n7889.n504 VSUBS 0.02608f
C526 w_n656_n7889.n505 VSUBS 0.01696f
C527 w_n656_n7889.n506 VSUBS 0.00707f
C528 w_n656_n7889.n507 VSUBS 0
C529 w_n656_n7889.n508 VSUBS 0
C530 w_n656_n7889.n509 VSUBS 0.00316f
C531 w_n656_n7889.n510 VSUBS 0
C532 w_n656_n7889.n511 VSUBS 0
C533 w_n656_n7889.n512 VSUBS 0
C534 w_n656_n7889.t7 VSUBS 0.10132f
C535 w_n656_n7889.n513 VSUBS 0.09778f
C536 w_n656_n7889.n514 VSUBS 0
C537 w_n656_n7889.n515 VSUBS 0
C538 w_n656_n7889.n516 VSUBS 0
C539 w_n656_n7889.n517 VSUBS 0
C540 w_n656_n7889.n518 VSUBS 0
C541 w_n656_n7889.n519 VSUBS 0.00153f
C542 w_n656_n7889.n520 VSUBS 0.01007f
C543 w_n656_n7889.n522 VSUBS 0.0021f
C544 w_n656_n7889.n523 VSUBS 0.00118f
C545 w_n656_n7889.n524 VSUBS 0
C546 w_n656_n7889.n525 VSUBS 0
C547 w_n656_n7889.n526 VSUBS 0.00167f
C548 w_n656_n7889.n528 VSUBS 0.00181f
C549 w_n656_n7889.n529 VSUBS 0.0013f
C550 w_n656_n7889.n530 VSUBS 0.16155f
C551 w_n656_n7889.n531 VSUBS 0.0013f
C552 w_n656_n7889.n532 VSUBS 0.00181f
C553 w_n656_n7889.n533 VSUBS 0.00181f
C554 w_n656_n7889.n535 VSUBS 1.46619f
C555 w_n656_n7889.n537 VSUBS 0.00181f
C556 w_n656_n7889.n538 VSUBS 0.0013f
C557 w_n656_n7889.n539 VSUBS 0.21115f
C558 w_n656_n7889.n540 VSUBS 0.0013f
C559 w_n656_n7889.n541 VSUBS 0.0013f
C560 w_n656_n7889.n542 VSUBS 0.00181f
C561 w_n656_n7889.n543 VSUBS 0.00181f
C562 w_n656_n7889.n544 VSUBS 0.0013f
C563 w_n656_n7889.n545 VSUBS 0.14596f
C564 w_n656_n7889.n546 VSUBS 0.0013f
C565 w_n656_n7889.n547 VSUBS 0.00181f
C566 w_n656_n7889.n548 VSUBS 0.00181f
C567 w_n656_n7889.n549 VSUBS 0.00181f
C568 w_n656_n7889.n550 VSUBS 0.00181f
C569 w_n656_n7889.n551 VSUBS 0.00181f
C570 w_n656_n7889.n552 VSUBS 0.00181f
C571 w_n656_n7889.n553 VSUBS 0.00181f
C572 w_n656_n7889.n554 VSUBS 0.0013f
C573 w_n656_n7889.n555 VSUBS 0.00181f
C574 w_n656_n7889.n556 VSUBS 0.00181f
C575 w_n656_n7889.n557 VSUBS 0.00181f
C576 w_n656_n7889.n558 VSUBS 0.0013f
C577 w_n656_n7889.n559 VSUBS 0.12045f
C578 w_n656_n7889.n560 VSUBS 0.0013f
C579 w_n656_n7889.n561 VSUBS 0.0013f
C580 w_n656_n7889.n562 VSUBS 0.03118f
C581 w_n656_n7889.n563 VSUBS 0.0013f
C582 w_n656_n7889.n564 VSUBS 0.00181f
C583 w_n656_n7889.n566 VSUBS 0.01375f
C584 w_n656_n7889.n567 VSUBS 0.00166f
C585 w_n656_n7889.n568 VSUBS 0.00181f
C586 w_n656_n7889.n569 VSUBS 0.00147f
C587 w_n656_n7889.n570 VSUBS 0.00181f
C588 w_n656_n7889.n571 VSUBS 0.00181f
C589 w_n656_n7889.n572 VSUBS 0.0013f
C590 w_n656_n7889.n573 VSUBS 0.21185f
C591 w_n656_n7889.n574 VSUBS 0.00138f
C592 w_n656_n7889.n575 VSUBS 0
C593 w_n656_n7889.n576 VSUBS 0
C594 w_n656_n7889.n577 VSUBS 0
C595 w_n656_n7889.n578 VSUBS 0
C596 w_n656_n7889.n579 VSUBS 0
C597 w_n656_n7889.n580 VSUBS 0
C598 w_n656_n7889.n581 VSUBS 0
C599 w_n656_n7889.n582 VSUBS 0
C600 w_n656_n7889.n583 VSUBS 0
C601 w_n656_n7889.n584 VSUBS 0.01182f
C602 w_n656_n7889.n585 VSUBS 0.05223f
C603 w_n656_n7889.t14 VSUBS 0.02373f
C604 w_n656_n7889.n586 VSUBS 0.07646f
C605 w_n656_n7889.n587 VSUBS 0.01451f
C606 w_n656_n7889.t12 VSUBS 0.01891f
C607 w_n656_n7889.n588 VSUBS 0.01791f
C608 w_n656_n7889.n589 VSUBS 0.01596f
C609 w_n656_n7889.n590 VSUBS 0.01479f
C610 w_n656_n7889.n591 VSUBS 0.00632f
C611 w_n656_n7889.n592 VSUBS 0.00586f
C612 w_n656_n7889.n593 VSUBS 0.00409f
C613 w_n656_n7889.n594 VSUBS 0
C614 w_n656_n7889.n595 VSUBS 0.11975f
C615 w_n656_n7889.t13 VSUBS 0.1077f
C616 w_n656_n7889.n596 VSUBS 0.04676f
C617 w_n656_n7889.n597 VSUBS 0.02055f
C618 w_n656_n7889.n598 VSUBS 0.0013f
C619 w_n656_n7889.n599 VSUBS 0.00181f
C620 w_n656_n7889.n600 VSUBS 0.00147f
C621 w_n656_n7889.n601 VSUBS 0.00426f
C622 w_n656_n7889.n602 VSUBS 0.01958f
C623 w_n656_n7889.n603 VSUBS 0.03368f
C624 w_n656_n7889.n604 VSUBS 0.02228f
C625 w_n656_n7889.n605 VSUBS 0.16155f
C626 w_n656_n7889.n606 VSUBS 0.00798f
C627 w_n656_n7889.n607 VSUBS 0.01518f
C628 w_n656_n7889.n608 VSUBS 0.01687f
C629 w_n656_n7889.n609 VSUBS 0.00552f
C630 w_n656_n7889.n610 VSUBS 0.00181f
C631 w_n656_n7889.n611 VSUBS 0.00181f
C632 w_n656_n7889.n612 VSUBS 0.00181f
C633 w_n656_n7889.n613 VSUBS 0.00181f
C634 w_n656_n7889.n614 VSUBS 0.057f
C635 w_n656_n7889.n616 VSUBS 0.00439f
C636 w_n656_n7889.n617 VSUBS 0.00147f
C637 w_n656_n7889.n618 VSUBS 0.00181f
C638 w_n656_n7889.n619 VSUBS 0.00799f
C639 w_n656_n7889.n620 VSUBS 0.0013f
C640 w_n656_n7889.t23 VSUBS 0.02905f
C641 w_n656_n7889.n621 VSUBS 0.05809f
C642 w_n656_n7889.n622 VSUBS 0.00799f
C643 w_n656_n7889.n623 VSUBS 0.0013f
C644 w_n656_n7889.n624 VSUBS 0.00147f
C645 w_n656_n7889.t22 VSUBS 0.00965f
C646 w_n656_n7889.t24 VSUBS 0.0786f
C647 w_n656_n7889.n625 VSUBS 0.03458f
C648 w_n656_n7889.n626 VSUBS 0.01397f
C649 w_n656_n7889.n627 VSUBS 0.06339f
C650 w_n656_n7889.n629 VSUBS 0.09576f
C651 w_n656_n7889.n630 VSUBS 0.02079f
C652 w_n656_n7889.n631 VSUBS 0.00637f
C653 w_n656_n7889.n632 VSUBS 0.00181f
C654 w_n656_n7889.n633 VSUBS 0.00181f
C655 w_n656_n7889.n634 VSUBS 0.00181f
C656 w_n656_n7889.n635 VSUBS 0.00181f
C657 w_n656_n7889.n636 VSUBS 0.00181f
C658 w_n656_n7889.n637 VSUBS 0.0013f
C659 w_n656_n7889.n638 VSUBS 0.0013f
C660 w_n656_n7889.n639 VSUBS 0.00181f
C661 w_n656_n7889.n640 VSUBS 0.00181f
C662 w_n656_n7889.n641 VSUBS 0.0013f
C663 w_n656_n7889.n642 VSUBS 0.03522f
C664 w_n656_n7889.n643 VSUBS 0.03522f
C665 w_n656_n7889.t29 VSUBS 0.02905f
C666 w_n656_n7889.n644 VSUBS 0.05192f
C667 w_n656_n7889.n645 VSUBS 0.0013f
C668 w_n656_n7889.n646 VSUBS 0.00181f
C669 w_n656_n7889.n647 VSUBS 0.00181f
C670 w_n656_n7889.n648 VSUBS 0.00181f
C671 w_n656_n7889.n649 VSUBS 0.0013f
C672 w_n656_n7889.n650 VSUBS 0.04321f
C673 w_n656_n7889.n651 VSUBS 0.0013f
C674 w_n656_n7889.n652 VSUBS 0.00181f
C675 w_n656_n7889.n653 VSUBS 0.00121f
C676 w_n656_n7889.n654 VSUBS 0.05325f
C677 w_n656_n7889.n656 VSUBS 0.00181f
C678 w_n656_n7889.n657 VSUBS 0.0013f
C679 w_n656_n7889.n658 VSUBS 0.05192f
C680 w_n656_n7889.n659 VSUBS 0.0013f
C681 w_n656_n7889.n660 VSUBS 0.00181f
C682 w_n656_n7889.n661 VSUBS 0.00181f
C683 w_n656_n7889.n662 VSUBS 0.00181f
C684 w_n656_n7889.n663 VSUBS 0.00181f
C685 w_n656_n7889.n664 VSUBS 0.00147f
C686 w_n656_n7889.n665 VSUBS 0.00181f
C687 w_n656_n7889.n666 VSUBS 0.0013f
C688 w_n656_n7889.n667 VSUBS 0.04321f
C689 w_n656_n7889.n668 VSUBS 0.0013f
C690 w_n656_n7889.n669 VSUBS 0.00181f
C691 w_n656_n7889.n670 VSUBS 0.00147f
C692 w_n656_n7889.n671 VSUBS 0.00439f
C693 w_n656_n7889.n672 VSUBS 0.01397f
C694 w_n656_n7889.n673 VSUBS 0.02079f
C695 w_n656_n7889.n674 VSUBS 0.01428f
C696 w_n656_n7889.n675 VSUBS 0.19697f
C697 w_n656_n7889.n676 VSUBS -0.11528f
C698 rx_frontend_62479d0d_0/Unnamed_23824e57_0/a_n86_n481# VSUBS 0.16188f
C699 rx_frontend_62479d0d_0/Unnamed_23824e57_0/a_n292_n481# VSUBS 0.47364f $ **FLOATING
C700 rx_frontend_62479d0d_0/Unnamed_23824e57_0/a_n142_n689# VSUBS 0.13155f
C701 w_3076_n2880# VSUBS 0.02994f
C702 rx_frontend_62479d0d_0/Unnamed_6ab50a26_0/a_n86_n481# VSUBS 0.16188f $ **FLOATING
C703 rx_frontend_62479d0d_0/Unnamed_6ab50a26_0/a_n292_n481# VSUBS 0.47364f $ **FLOATING
C704 rx_frontend_62479d0d_0/Unnamed_6ab50a26_0/a_n142_n689# VSUBS 0.13155f
C705 w_3076_60# VSUBS -0.42039f
C706 rx_frontend_62479d0d_0/lna_block_62479d0d_0/Unnamed_3c60cbf2_0/a_n520_n2180# VSUBS 1.76105f
C707 rx_frontend_62479d0d_0/lna_block_62479d0d_0/Unnamed_3c60cbf2_0/a_n370_n2390# VSUBS 0.25367f
.ends
