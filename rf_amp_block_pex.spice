* NGSPICE file created from rf_amp_block.ext - technology: gf180mcuD

.subckt Unnamed_cb29a60b a_n86_n781# w_n1078_n1209# a_n292_n781# a_n142_n989# VSUBS
X0 a_n86_n781# a_n142_n989# a_n292_n781# w_n1078_n1209# pfet_03v3 ad=2.58p pd=6.86u as=4.5p ps=13.5u w=6u l=0.28u
X1 w_n1078_n1209# w_n1078_n1209# w_n1078_n1209# w_n1078_n1209# pfet_03v3 ad=4.38p pd=13.46u as=17.52p ps=53.84u w=6u l=0.28u
X2 w_n1078_n1209# w_n1078_n1209# w_n1078_n1209# w_n1078_n1209# pfet_03v3 ad=4.38p pd=13.46u as=0 ps=0 w=6u l=0.28u
X3 a_n292_n781# a_n142_n989# a_n86_n781# w_n1078_n1209# pfet_03v3 ad=4.5p pd=13.5u as=2.58p ps=6.86u w=6u l=0.28u
C0 w_n1078_n1209# a_n292_n781# 1.31248f
C1 w_n1078_n1209# a_n142_n989# 0.70438f
C2 w_n1078_n1209# a_n86_n781# 0.53548f
C3 a_n292_n781# a_n142_n989# 0.14859f
C4 a_n292_n781# a_n86_n781# 2.07055f
C5 a_n142_n989# a_n86_n781# 0.21114f
C6 a_n86_n781# VSUBS 0.02943f
C7 a_n292_n781# VSUBS 0.20603f
C8 a_n142_n989# VSUBS 0.09366f
C9 w_n1078_n1209# VSUBS 17.4889f
.ends

.subckt Unnamed_1f5ec66d a_n142_n1189# w_n1578_n1909# a_n86_n981# a_n292_n981# VSUBS
X0 a_n292_n981# a_n142_n1189# a_n86_n981# w_n1578_n1909# nfet_03v3 ad=6p pd=17.5u as=3.44p ps=8.86u w=8u l=0.28u
X1 a_n86_n981# a_n142_n1189# a_n292_n981# w_n1578_n1909# nfet_03v3 ad=3.44p pd=8.86u as=6p ps=17.5u w=8u l=0.28u
X2 w_n1578_n1909# w_n1578_n1909# w_n1578_n1909# w_n1578_n1909# nfet_03v3 ad=5.84p pd=17.46u as=23.36p ps=69.84u w=8u l=0.28u
X3 w_n1578_n1909# w_n1578_n1909# w_n1578_n1909# w_n1578_n1909# nfet_03v3 ad=5.84p pd=17.46u as=0 ps=0 w=8u l=0.28u
C0 a_n86_n981# a_n292_n981# 2.58576f
C1 a_n142_n1189# w_n1578_n1909# 0.6672f
C2 a_n142_n1189# a_n86_n981# 0.25198f
C3 a_n142_n1189# a_n292_n981# 0.18361f
C4 a_n86_n981# w_n1578_n1909# 0.30493f
C5 w_n1578_n1909# a_n292_n981# 1.05692f
C6 a_n86_n981# VSUBS 0.26004f
C7 a_n292_n981# VSUBS 0.83589f
C8 a_n142_n1189# VSUBS 0.13816f
C9 w_n1578_n1909# VSUBS 4.92605f
.ends

.subckt rf_amp_block_62479d0d w_n1578_n1909# VSUBS
XUnnamed_cb29a60b_0 w_n1578_n1909# w_n1578_n1909# w_n1578_n1909# w_n1578_n1909# VSUBS
+ Unnamed_cb29a60b
XUnnamed_1f5ec66d_0 Unnamed_1f5ec66d_0/a_n142_n1189# w_n1578_n1909# w_n1578_n1909#
+ Unnamed_1f5ec66d_0/a_n292_n981# VSUBS Unnamed_1f5ec66d
C0 Unnamed_1f5ec66d_0/a_n142_n1189# w_n1578_n1909# 0.00217f
C1 Unnamed_1f5ec66d_0/a_n292_n981# w_n1578_n1909# 0.00207f
C2 Unnamed_1f5ec66d_0/a_n292_n981# VSUBS 0.83589f
C3 Unnamed_1f5ec66d_0/a_n142_n1189# VSUBS 0.13816f
C4 w_n1578_n1909# VSUBS 21.91559f
.ends

.subckt rf_amp_block
Xrf_amp_block_62479d0d_0 w_n1578_n1909# VSUBS rf_amp_block_62479d0d
X0 w_n1578_n1909.t12 w_n1578_n1909.t10 w_n1578_n1909.t12 w_n1578_n1909.t11 pfet_03v3 ad=4.5p pd=13.5u as=2.58p ps=6.86u w=0 l=0
X1 rf_amp_block_62479d0d_0/Unnamed_1f5ec66d_0/a_n292_n981.t1 rf_amp_block_62479d0d_0/Unnamed_1f5ec66d_0/a_n142_n1189# w_n1578_n1909.t3 w_n1578_n1909.t2 nfet_03v3 ad=6p pd=17.5u as=3.44p ps=8.86u w=0 l=0
X2 w_n1578_n1909.t21 w_n1578_n1909.t19 w_n1578_n1909.t21 w_n1578_n1909.t20 pfet_03v3 ad=2.58p pd=6.86u as=4.5p ps=13.5u w=0 l=0
X3 w_n1578_n1909.t18 w_n1578_n1909.t16 w_n1578_n1909.t18 w_n1578_n1909.t17 pfet_03v3 ad=4.38p pd=13.46u as=0 ps=0 w=0 l=0
X4 w_n1578_n1909.t15 w_n1578_n1909.t13 w_n1578_n1909.t15 w_n1578_n1909.t14 pfet_03v3 ad=4.38p pd=13.46u as=0 ps=0 w=0 l=0
X5 w_n1578_n1909.t1 rf_amp_block_62479d0d_0/Unnamed_1f5ec66d_0/a_n142_n1189# rf_amp_block_62479d0d_0/Unnamed_1f5ec66d_0/a_n292_n981.t0 w_n1578_n1909.t0 nfet_03v3 ad=3.44p pd=8.86u as=6p ps=17.5u w=0 l=0
X6 w_n1578_n1909.t9 w_n1578_n1909.t7 w_n1578_n1909.t9 w_n1578_n1909.t8 nfet_03v3 ad=5.84p pd=17.46u as=0 ps=0 w=0 l=0
X7 w_n1578_n1909.t6 w_n1578_n1909.t4 w_n1578_n1909.t6 w_n1578_n1909.t5 nfet_03v3 ad=5.84p pd=17.46u as=0 ps=0 w=0 l=0
R0 w_n1578_n1909.n188 w_n1578_n1909.n187 495.295
R1 w_n1578_n1909.n187 w_n1578_n1909.n0 222.924
R2 w_n1578_n1909.n186 w_n1578_n1909.n1 150.404
R3 w_n1578_n1909.n186 w_n1578_n1909.n2 150.404
R4 w_n1578_n1909.n143 w_n1578_n1909.n139 150.404
R5 w_n1578_n1909.n168 w_n1578_n1909.n126 134.09
R6 w_n1578_n1909.n168 w_n1578_n1909.n167 134.09
R7 w_n1578_n1909.n166 w_n1578_n1909.n130 134.09
R8 w_n1578_n1909.n160 w_n1578_n1909.n7 134.09
R9 w_n1578_n1909.n178 w_n1578_n1909.n7 134.09
R10 w_n1578_n1909.n136 w_n1578_n1909.t7 122.249
R11 w_n1578_n1909.n183 w_n1578_n1909.t4 122.249
R12 w_n1578_n1909.n58 w_n1578_n1909.n53 117.864
R13 w_n1578_n1909.n100 w_n1578_n1909.n86 117.864
R14 w_n1578_n1909.n167 w_n1578_n1909.t2 105.597
R15 w_n1578_n1909.n160 w_n1578_n1909.t0 105.597
R16 w_n1578_n1909.n39 w_n1578_n1909.t10 100.615
R17 w_n1578_n1909.n39 w_n1578_n1909.t19 100.615
R18 w_n1578_n1909.n92 w_n1578_n1909.t13 96.1782
R19 w_n1578_n1909.n55 w_n1578_n1909.t16 96.1782
R20 w_n1578_n1909.n145 w_n1578_n1909.n139 88.611
R21 w_n1578_n1909.n144 w_n1578_n1909.t8 68.7215
R22 w_n1578_n1909.t5 w_n1578_n1909.n0 68.7215
R23 w_n1578_n1909.n65 w_n1578_n1909.n46 66.1709
R24 w_n1578_n1909.n113 w_n1578_n1909.n46 66.1709
R25 w_n1578_n1909.n107 w_n1578_n1909.n75 66.1709
R26 w_n1578_n1909.n106 w_n1578_n1909.n105 66.1709
R27 w_n1578_n1909.n105 w_n1578_n1909.n80 66.1709
R28 w_n1578_n1909.t8 w_n1578_n1909.n126 65.3692
R29 w_n1578_n1909.n178 w_n1578_n1909.t5 65.3692
R30 w_n1578_n1909.n58 w_n1578_n1909.n57 55.4502
R31 w_n1578_n1909.n98 w_n1578_n1909.n86 55.4502
R32 w_n1578_n1909.n113 w_n1578_n1909.t11 52.1097
R33 w_n1578_n1909.t20 w_n1578_n1909.n106 52.1097
R34 w_n1578_n1909.n56 w_n1578_n1909.t17 33.9128
R35 w_n1578_n1909.n99 w_n1578_n1909.t14 33.9128
R36 w_n1578_n1909.n65 w_n1578_n1909.t17 32.2586
R37 w_n1578_n1909.t14 w_n1578_n1909.n80 32.2586
R38 w_n1578_n1909.t2 w_n1578_n1909.n166 28.4946
R39 w_n1578_n1909.t0 w_n1578_n1909.n130 28.4946
R40 w_n1578_n1909.n146 w_n1578_n1909.n138 15.5561
R41 w_n1578_n1909.n138 w_n1578_n1909.n127 15.5561
R42 w_n1578_n1909.n128 w_n1578_n1909.n127 15.5561
R43 w_n1578_n1909.n129 w_n1578_n1909.n128 15.5561
R44 w_n1578_n1909.n132 w_n1578_n1909.n129 15.5561
R45 w_n1578_n1909.n159 w_n1578_n1909.n132 15.5561
R46 w_n1578_n1909.n159 w_n1578_n1909.n6 15.5561
R47 w_n1578_n1909.n179 w_n1578_n1909.n6 15.5561
R48 w_n1578_n1909.n179 w_n1578_n1909.n2 15.5561
R49 w_n1578_n1909.n143 w_n1578_n1909.n124 15.5561
R50 w_n1578_n1909.n169 w_n1578_n1909.n124 15.5561
R51 w_n1578_n1909.n169 w_n1578_n1909.n125 15.5561
R52 w_n1578_n1909.n165 w_n1578_n1909.n125 15.5561
R53 w_n1578_n1909.n165 w_n1578_n1909.n162 15.5561
R54 w_n1578_n1909.n162 w_n1578_n1909.n161 15.5561
R55 w_n1578_n1909.n161 w_n1578_n1909.n8 15.5561
R56 w_n1578_n1909.n177 w_n1578_n1909.n8 15.5561
R57 w_n1578_n1909.n177 w_n1578_n1909.n1 15.5561
R58 w_n1578_n1909.n75 w_n1578_n1909.t11 14.0617
R59 w_n1578_n1909.n107 w_n1578_n1909.t20 14.0617
R60 w_n1578_n1909.n66 w_n1578_n1909.n52 14.0005
R61 w_n1578_n1909.n66 w_n1578_n1909.n47 14.0005
R62 w_n1578_n1909.n112 w_n1578_n1909.n47 14.0005
R63 w_n1578_n1909.n112 w_n1578_n1909.n48 14.0005
R64 w_n1578_n1909.n108 w_n1578_n1909.n48 14.0005
R65 w_n1578_n1909.n108 w_n1578_n1909.n74 14.0005
R66 w_n1578_n1909.n104 w_n1578_n1909.n74 14.0005
R67 w_n1578_n1909.n104 w_n1578_n1909.n81 14.0005
R68 w_n1578_n1909.n100 w_n1578_n1909.n81 14.0005
R69 w_n1578_n1909.n64 w_n1578_n1909.n53 14.0005
R70 w_n1578_n1909.n64 w_n1578_n1909.n44 14.0005
R71 w_n1578_n1909.n114 w_n1578_n1909.n44 14.0005
R72 w_n1578_n1909.n114 w_n1578_n1909.n45 14.0005
R73 w_n1578_n1909.n77 w_n1578_n1909.n45 14.0005
R74 w_n1578_n1909.n78 w_n1578_n1909.n77 14.0005
R75 w_n1578_n1909.n79 w_n1578_n1909.n78 14.0005
R76 w_n1578_n1909.n87 w_n1578_n1909.n79 14.0005
R77 w_n1578_n1909.n97 w_n1578_n1909.n87 14.0005
R78 w_n1578_n1909.n40 w_n1578_n1909.n39 12.5005
R79 w_n1578_n1909.n52 w_n1578_n1909.n51 6.3005
R80 w_n1578_n1909.n67 w_n1578_n1909.n66 6.3005
R81 w_n1578_n1909.n66 w_n1578_n1909.n65 6.3005
R82 w_n1578_n1909.n49 w_n1578_n1909.n47 6.3005
R83 w_n1578_n1909.n47 w_n1578_n1909.n46 6.3005
R84 w_n1578_n1909.n112 w_n1578_n1909.n111 6.3005
R85 w_n1578_n1909.n113 w_n1578_n1909.n112 6.3005
R86 w_n1578_n1909.n110 w_n1578_n1909.n48 6.3005
R87 w_n1578_n1909.n75 w_n1578_n1909.n48 6.3005
R88 w_n1578_n1909.n109 w_n1578_n1909.n108 6.3005
R89 w_n1578_n1909.n108 w_n1578_n1909.n107 6.3005
R90 w_n1578_n1909.n74 w_n1578_n1909.n73 6.3005
R91 w_n1578_n1909.n106 w_n1578_n1909.n74 6.3005
R92 w_n1578_n1909.n104 w_n1578_n1909.n103 6.3005
R93 w_n1578_n1909.n105 w_n1578_n1909.n104 6.3005
R94 w_n1578_n1909.n102 w_n1578_n1909.n81 6.3005
R95 w_n1578_n1909.n81 w_n1578_n1909.n80 6.3005
R96 w_n1578_n1909.n101 w_n1578_n1909.n100 6.3005
R97 w_n1578_n1909.n100 w_n1578_n1909.n99 6.3005
R98 w_n1578_n1909.n97 w_n1578_n1909.n96 6.3005
R99 w_n1578_n1909.n90 w_n1578_n1909.n87 6.3005
R100 w_n1578_n1909.n87 w_n1578_n1909.n80 6.3005
R101 w_n1578_n1909.n89 w_n1578_n1909.n79 6.3005
R102 w_n1578_n1909.n105 w_n1578_n1909.n79 6.3005
R103 w_n1578_n1909.n88 w_n1578_n1909.n78 6.3005
R104 w_n1578_n1909.n106 w_n1578_n1909.n78 6.3005
R105 w_n1578_n1909.n77 w_n1578_n1909.n76 6.3005
R106 w_n1578_n1909.n107 w_n1578_n1909.n77 6.3005
R107 w_n1578_n1909.n45 w_n1578_n1909.n42 6.3005
R108 w_n1578_n1909.n75 w_n1578_n1909.n45 6.3005
R109 w_n1578_n1909.n115 w_n1578_n1909.n114 6.3005
R110 w_n1578_n1909.n114 w_n1578_n1909.n113 6.3005
R111 w_n1578_n1909.n44 w_n1578_n1909.n43 6.3005
R112 w_n1578_n1909.n46 w_n1578_n1909.n44 6.3005
R113 w_n1578_n1909.n64 w_n1578_n1909.n63 6.3005
R114 w_n1578_n1909.n65 w_n1578_n1909.n64 6.3005
R115 w_n1578_n1909.n54 w_n1578_n1909.n53 6.3005
R116 w_n1578_n1909.n56 w_n1578_n1909.n53 6.3005
R117 w_n1578_n1909.n172 w_n1578_n1909.n120 6.0843
R118 w_n1578_n1909.n141 w_n1578_n1909.n140 6.02076
R119 w_n1578_n1909.n185 w_n1578_n1909.n3 6.02076
R120 w_n1578_n1909.n93 w_n1578_n1909.n85 5.8251
R121 w_n1578_n1909.n59 w_n1578_n1909.n50 5.8251
R122 w_n1578_n1909.n175 w_n1578_n1909.n1 5.2005
R123 w_n1578_n1909.n1 w_n1578_n1909.n0 5.2005
R124 w_n1578_n1909.n177 w_n1578_n1909.n176 5.2005
R125 w_n1578_n1909.n178 w_n1578_n1909.n177 5.2005
R126 w_n1578_n1909.n9 w_n1578_n1909.n8 5.2005
R127 w_n1578_n1909.n8 w_n1578_n1909.n7 5.2005
R128 w_n1578_n1909.n161 w_n1578_n1909.n131 5.2005
R129 w_n1578_n1909.n161 w_n1578_n1909.n160 5.2005
R130 w_n1578_n1909.n163 w_n1578_n1909.n162 5.2005
R131 w_n1578_n1909.n162 w_n1578_n1909.n130 5.2005
R132 w_n1578_n1909.n165 w_n1578_n1909.n164 5.2005
R133 w_n1578_n1909.n166 w_n1578_n1909.n165 5.2005
R134 w_n1578_n1909.n125 w_n1578_n1909.n123 5.2005
R135 w_n1578_n1909.n167 w_n1578_n1909.n125 5.2005
R136 w_n1578_n1909.n170 w_n1578_n1909.n169 5.2005
R137 w_n1578_n1909.n169 w_n1578_n1909.n168 5.2005
R138 w_n1578_n1909.n124 w_n1578_n1909.n122 5.2005
R139 w_n1578_n1909.n126 w_n1578_n1909.n124 5.2005
R140 w_n1578_n1909.n143 w_n1578_n1909.n142 5.2005
R141 w_n1578_n1909.n144 w_n1578_n1909.n143 5.2005
R142 w_n1578_n1909.n181 w_n1578_n1909.n2 5.2005
R143 w_n1578_n1909.n2 w_n1578_n1909.n0 5.2005
R144 w_n1578_n1909.n180 w_n1578_n1909.n179 5.2005
R145 w_n1578_n1909.n179 w_n1578_n1909.n178 5.2005
R146 w_n1578_n1909.n6 w_n1578_n1909.n5 5.2005
R147 w_n1578_n1909.n7 w_n1578_n1909.n6 5.2005
R148 w_n1578_n1909.n159 w_n1578_n1909.n158 5.2005
R149 w_n1578_n1909.n160 w_n1578_n1909.n159 5.2005
R150 w_n1578_n1909.n133 w_n1578_n1909.n132 5.2005
R151 w_n1578_n1909.n132 w_n1578_n1909.n130 5.2005
R152 w_n1578_n1909.n153 w_n1578_n1909.n129 5.2005
R153 w_n1578_n1909.n166 w_n1578_n1909.n129 5.2005
R154 w_n1578_n1909.n152 w_n1578_n1909.n128 5.2005
R155 w_n1578_n1909.n167 w_n1578_n1909.n128 5.2005
R156 w_n1578_n1909.n151 w_n1578_n1909.n127 5.2005
R157 w_n1578_n1909.n168 w_n1578_n1909.n127 5.2005
R158 w_n1578_n1909.n138 w_n1578_n1909.n135 5.2005
R159 w_n1578_n1909.n138 w_n1578_n1909.n126 5.2005
R160 w_n1578_n1909.n147 w_n1578_n1909.n146 5.2005
R161 w_n1578_n1909.n23 w_n1578_n1909.n20 5.11193
R162 w_n1578_n1909.n148 w_n1578_n1909.n137 4.92413
R163 w_n1578_n1909.n184 w_n1578_n1909.n182 4.92413
R164 w_n1578_n1909.n95 w_n1578_n1909.n94 4.92413
R165 w_n1578_n1909.n61 w_n1578_n1909.n60 4.92413
R166 w_n1578_n1909.n25 w_n1578_n1909.n20 4.8155
R167 w_n1578_n1909.n38 w_n1578_n1909.n37 4.6445
R168 w_n1578_n1909.n38 w_n1578_n1909.n13 4.6445
R169 w_n1578_n1909.n149 w_n1578_n1909.n135 4.5005
R170 w_n1578_n1909.n151 w_n1578_n1909.n150 4.5005
R171 w_n1578_n1909.n152 w_n1578_n1909.n134 4.5005
R172 w_n1578_n1909.n154 w_n1578_n1909.n153 4.5005
R173 w_n1578_n1909.n155 w_n1578_n1909.n133 4.5005
R174 w_n1578_n1909.n158 w_n1578_n1909.n157 4.5005
R175 w_n1578_n1909.n156 w_n1578_n1909.n5 4.5005
R176 w_n1578_n1909.n180 w_n1578_n1909.n4 4.5005
R177 w_n1578_n1909.n182 w_n1578_n1909.n181 4.5005
R178 w_n1578_n1909.n148 w_n1578_n1909.n147 4.5005
R179 w_n1578_n1909.n51 w_n1578_n1909.n50 4.5005
R180 w_n1578_n1909.n68 w_n1578_n1909.n67 4.5005
R181 w_n1578_n1909.n69 w_n1578_n1909.n49 4.5005
R182 w_n1578_n1909.n111 w_n1578_n1909.n70 4.5005
R183 w_n1578_n1909.n110 w_n1578_n1909.n71 4.5005
R184 w_n1578_n1909.n109 w_n1578_n1909.n72 4.5005
R185 w_n1578_n1909.n82 w_n1578_n1909.n73 4.5005
R186 w_n1578_n1909.n103 w_n1578_n1909.n83 4.5005
R187 w_n1578_n1909.n102 w_n1578_n1909.n84 4.5005
R188 w_n1578_n1909.n101 w_n1578_n1909.n85 4.5005
R189 w_n1578_n1909.n63 w_n1578_n1909.n62 4.5005
R190 w_n1578_n1909.n43 w_n1578_n1909.n11 4.5005
R191 w_n1578_n1909.n89 w_n1578_n1909.n10 4.5005
R192 w_n1578_n1909.n91 w_n1578_n1909.n90 4.5005
R193 w_n1578_n1909.n96 w_n1578_n1909.n95 4.5005
R194 w_n1578_n1909.n61 w_n1578_n1909.n54 4.5005
R195 w_n1578_n1909.n21 w_n1578_n1909.n19 4.5005
R196 w_n1578_n1909.n29 w_n1578_n1909.n17 4.5005
R197 w_n1578_n1909.n33 w_n1578_n1909.n15 4.5005
R198 w_n1578_n1909.n35 w_n1578_n1909.n34 4.5005
R199 w_n1578_n1909.n25 w_n1578_n1909.n24 4.5005
R200 w_n1578_n1909.n26 w_n1578_n1909.n19 4.5005
R201 w_n1578_n1909.n29 w_n1578_n1909.n28 4.5005
R202 w_n1578_n1909.n27 w_n1578_n1909.n15 4.5005
R203 w_n1578_n1909.n35 w_n1578_n1909.n16 4.5005
R204 w_n1578_n1909.n36 w_n1578_n1909.n13 4.5005
R205 w_n1578_n1909.n24 w_n1578_n1909.n23 4.5005
R206 w_n1578_n1909.n19 w_n1578_n1909.n18 4.5005
R207 w_n1578_n1909.n30 w_n1578_n1909.n29 4.5005
R208 w_n1578_n1909.n31 w_n1578_n1909.n15 4.5005
R209 w_n1578_n1909.n35 w_n1578_n1909.n14 4.5005
R210 w_n1578_n1909.n37 w_n1578_n1909.n36 4.5005
R211 w_n1578_n1909.n122 w_n1578_n1909.n121 4.5005
R212 w_n1578_n1909.n171 w_n1578_n1909.n170 4.5005
R213 w_n1578_n1909.n173 w_n1578_n1909.n9 4.5005
R214 w_n1578_n1909.n176 w_n1578_n1909.n174 4.5005
R215 w_n1578_n1909.n175 w_n1578_n1909.n3 4.5005
R216 w_n1578_n1909.n142 w_n1578_n1909.n141 4.5005
R217 w_n1578_n1909.n57 w_n1578_n1909.n52 3.16785
R218 w_n1578_n1909.n98 w_n1578_n1909.n97 3.16785
R219 w_n1578_n1909.n145 w_n1578_n1909.n144 3.06459
R220 w_n1578_n1909.n57 w_n1578_n1909.n56 2.96488
R221 w_n1578_n1909.n99 w_n1578_n1909.n98 2.96488
R222 w_n1578_n1909.n22 w_n1578_n1909.n21 2.45782
R223 w_n1578_n1909.n34 w_n1578_n1909.n12 2.42398
R224 w_n1578_n1909.n117 w_n1578_n1909.n116 2.21557
R225 w_n1578_n1909.n117 w_n1578_n1909.n41 2.21557
R226 w_n1578_n1909.n172 w_n1578_n1909.n119 2.21557
R227 w_n1578_n1909.n172 w_n1578_n1909.n118 2.21557
R228 w_n1578_n1909.n146 w_n1578_n1909.n145 2.06602
R229 w_n1578_n1909.n140 w_n1578_n1909.n137 1.00713
R230 w_n1578_n1909.n185 w_n1578_n1909.n184 1.00713
R231 w_n1578_n1909.n27 w_n1578_n1909.t21 0.974894
R232 w_n1578_n1909.n33 w_n1578_n1909.t12 0.974894
R233 w_n1578_n1909.n94 w_n1578_n1909.n93 0.811478
R234 w_n1578_n1909.n60 w_n1578_n1909.n59 0.811478
R235 w_n1578_n1909.n92 w_n1578_n1909.t15 0.805153
R236 w_n1578_n1909.n55 w_n1578_n1909.t18 0.805153
R237 w_n1578_n1909.n136 w_n1578_n1909.t9 0.795095
R238 w_n1578_n1909.n183 w_n1578_n1909.t6 0.795095
R239 w_n1578_n1909.t12 w_n1578_n1909.n32 0.502167
R240 w_n1578_n1909.n32 w_n1578_n1909.t21 0.502167
R241 w_n1578_n1909.n32 w_n1578_n1909.n31 0.473227
R242 w_n1578_n1909.n120 w_n1578_n1909.t3 0.339125
R243 w_n1578_n1909.n120 w_n1578_n1909.t1 0.339125
R244 w_n1578_n1909.n59 w_n1578_n1909.n58 0.3005
R245 w_n1578_n1909.n93 w_n1578_n1909.n86 0.3005
R246 w_n1578_n1909.n94 w_n1578_n1909.n92 0.282058
R247 w_n1578_n1909.n60 w_n1578_n1909.n55 0.282058
R248 w_n1578_n1909.n137 w_n1578_n1909.n136 0.282015
R249 w_n1578_n1909.n184 w_n1578_n1909.n183 0.282015
R250 w_n1578_n1909.n140 w_n1578_n1909.n139 0.2085
R251 w_n1578_n1909.n186 w_n1578_n1909.n185 0.2085
R252 w_n1578_n1909.n187 w_n1578_n1909.n186 0.2085
R253 w_n1578_n1909.n147 w_n1578_n1909.n135 0.1445
R254 w_n1578_n1909.n151 w_n1578_n1909.n135 0.1445
R255 w_n1578_n1909.n152 w_n1578_n1909.n151 0.1445
R256 w_n1578_n1909.n153 w_n1578_n1909.n152 0.1445
R257 w_n1578_n1909.n153 w_n1578_n1909.n133 0.1445
R258 w_n1578_n1909.n158 w_n1578_n1909.n133 0.1445
R259 w_n1578_n1909.n158 w_n1578_n1909.n5 0.1445
R260 w_n1578_n1909.n180 w_n1578_n1909.n5 0.1445
R261 w_n1578_n1909.n181 w_n1578_n1909.n180 0.1445
R262 w_n1578_n1909.n149 w_n1578_n1909.n148 0.1445
R263 w_n1578_n1909.n150 w_n1578_n1909.n149 0.1445
R264 w_n1578_n1909.n150 w_n1578_n1909.n134 0.1445
R265 w_n1578_n1909.n154 w_n1578_n1909.n134 0.1445
R266 w_n1578_n1909.n155 w_n1578_n1909.n154 0.1445
R267 w_n1578_n1909.n157 w_n1578_n1909.n155 0.1445
R268 w_n1578_n1909.n157 w_n1578_n1909.n156 0.1445
R269 w_n1578_n1909.n156 w_n1578_n1909.n4 0.1445
R270 w_n1578_n1909.n182 w_n1578_n1909.n4 0.1445
R271 w_n1578_n1909.n174 w_n1578_n1909.n173 0.1445
R272 w_n1578_n1909.n174 w_n1578_n1909.n3 0.1445
R273 w_n1578_n1909.n67 w_n1578_n1909.n51 0.1445
R274 w_n1578_n1909.n67 w_n1578_n1909.n49 0.1445
R275 w_n1578_n1909.n111 w_n1578_n1909.n49 0.1445
R276 w_n1578_n1909.n111 w_n1578_n1909.n110 0.1445
R277 w_n1578_n1909.n110 w_n1578_n1909.n109 0.1445
R278 w_n1578_n1909.n109 w_n1578_n1909.n73 0.1445
R279 w_n1578_n1909.n103 w_n1578_n1909.n73 0.1445
R280 w_n1578_n1909.n103 w_n1578_n1909.n102 0.1445
R281 w_n1578_n1909.n102 w_n1578_n1909.n101 0.1445
R282 w_n1578_n1909.n91 w_n1578_n1909.n10 0.1445
R283 w_n1578_n1909.n95 w_n1578_n1909.n91 0.1445
R284 w_n1578_n1909.n68 w_n1578_n1909.n50 0.1445
R285 w_n1578_n1909.n69 w_n1578_n1909.n68 0.1445
R286 w_n1578_n1909.n70 w_n1578_n1909.n69 0.1445
R287 w_n1578_n1909.n71 w_n1578_n1909.n70 0.1445
R288 w_n1578_n1909.n72 w_n1578_n1909.n71 0.1445
R289 w_n1578_n1909.n82 w_n1578_n1909.n72 0.1445
R290 w_n1578_n1909.n83 w_n1578_n1909.n82 0.1445
R291 w_n1578_n1909.n84 w_n1578_n1909.n83 0.1445
R292 w_n1578_n1909.n85 w_n1578_n1909.n84 0.1445
R293 w_n1578_n1909.n62 w_n1578_n1909.n61 0.1445
R294 w_n1578_n1909.n62 w_n1578_n1909.n11 0.1445
R295 w_n1578_n1909.n63 w_n1578_n1909.n54 0.1445
R296 w_n1578_n1909.n63 w_n1578_n1909.n43 0.1445
R297 w_n1578_n1909.n115 w_n1578_n1909.n43 0.1445
R298 w_n1578_n1909.n76 w_n1578_n1909.n42 0.1445
R299 w_n1578_n1909.n89 w_n1578_n1909.n88 0.1445
R300 w_n1578_n1909.n90 w_n1578_n1909.n89 0.1445
R301 w_n1578_n1909.n96 w_n1578_n1909.n90 0.1445
R302 w_n1578_n1909.n23 w_n1578_n1909.n18 0.1445
R303 w_n1578_n1909.n30 w_n1578_n1909.n18 0.1445
R304 w_n1578_n1909.n31 w_n1578_n1909.n30 0.1445
R305 w_n1578_n1909.n31 w_n1578_n1909.n14 0.1445
R306 w_n1578_n1909.n37 w_n1578_n1909.n14 0.1445
R307 w_n1578_n1909.n26 w_n1578_n1909.n25 0.1445
R308 w_n1578_n1909.n28 w_n1578_n1909.n26 0.1445
R309 w_n1578_n1909.n28 w_n1578_n1909.n27 0.1445
R310 w_n1578_n1909.n27 w_n1578_n1909.n16 0.1445
R311 w_n1578_n1909.n16 w_n1578_n1909.n13 0.1445
R312 w_n1578_n1909.n21 w_n1578_n1909.n17 0.1445
R313 w_n1578_n1909.n33 w_n1578_n1909.n17 0.1445
R314 w_n1578_n1909.n34 w_n1578_n1909.n33 0.1445
R315 w_n1578_n1909.n141 w_n1578_n1909.n121 0.1445
R316 w_n1578_n1909.n171 w_n1578_n1909.n121 0.1445
R317 w_n1578_n1909.n142 w_n1578_n1909.n122 0.1445
R318 w_n1578_n1909.n170 w_n1578_n1909.n122 0.1445
R319 w_n1578_n1909.n170 w_n1578_n1909.n123 0.1445
R320 w_n1578_n1909.n164 w_n1578_n1909.n163 0.1445
R321 w_n1578_n1909.n131 w_n1578_n1909.n9 0.1445
R322 w_n1578_n1909.n176 w_n1578_n1909.n9 0.1445
R323 w_n1578_n1909.n176 w_n1578_n1909.n175 0.1445
R324 w_n1578_n1909.n172 w_n1578_n1909.n117 0.120932
R325 w_n1578_n1909.n173 w_n1578_n1909.n172 0.1103
R326 w_n1578_n1909.n117 w_n1578_n1909.n10 0.1103
R327 w_n1578_n1909.n117 w_n1578_n1909.n11 0.1103
R328 w_n1578_n1909.n172 w_n1578_n1909.n171 0.1103
R329 w_n1578_n1909.n116 w_n1578_n1909.n115 0.0718661
R330 w_n1578_n1909.n76 w_n1578_n1909.n41 0.0718661
R331 w_n1578_n1909.n116 w_n1578_n1909.n42 0.0718661
R332 w_n1578_n1909.n88 w_n1578_n1909.n41 0.0718661
R333 w_n1578_n1909.n164 w_n1578_n1909.n119 0.0718661
R334 w_n1578_n1909.n131 w_n1578_n1909.n118 0.0718661
R335 w_n1578_n1909.n123 w_n1578_n1909.n119 0.0718661
R336 w_n1578_n1909.n163 w_n1578_n1909.n118 0.0718661
R337 w_n1578_n1909.n40 w_n1578_n1909.n38 0.0455
R338 w_n1578_n1909.n117 w_n1578_n1909.n40 0.029313
R339 w_n1578_n1909.n22 w_n1578_n1909.n20 0.0284544
R340 w_n1578_n1909.n24 w_n1578_n1909.n22 0.0266583
R341 w_n1578_n1909.n24 w_n1578_n1909.n19 0.0263993
R342 w_n1578_n1909.n29 w_n1578_n1909.n19 0.0263993
R343 w_n1578_n1909.n29 w_n1578_n1909.n15 0.0263993
R344 w_n1578_n1909.n35 w_n1578_n1909.n15 0.0263993
R345 w_n1578_n1909.n36 w_n1578_n1909.n35 0.0263993
R346 w_n1578_n1909.n38 w_n1578_n1909.n12 0.0141164
R347 w_n1578_n1909.n36 w_n1578_n1909.n12 0.0137097
R348 rf_amp_block_62479d0d_0/Unnamed_1f5ec66d_0/a_n292_n981.t0 rf_amp_block_62479d0d_0/Unnamed_1f5ec66d_0/a_n292_n981.t1 12.468
C0 rf_amp_block_62479d0d_0/Unnamed_1f5ec66d_0/a_n292_n981.t1 VSUBS 1.8f
C1 rf_amp_block_62479d0d_0/Unnamed_1f5ec66d_0/a_n292_n981.t0 VSUBS 1.8f
C2 w_n1578_n1909.n0 VSUBS 0.09586f
C3 w_n1578_n1909.n1 VSUBS 0.00903f
C4 w_n1578_n1909.n2 VSUBS 0.00903f
C5 w_n1578_n1909.n3 VSUBS 0.00747f
C6 w_n1578_n1909.n4 VSUBS 0.00227f
C7 w_n1578_n1909.n5 VSUBS 0.00227f
C8 w_n1578_n1909.n6 VSUBS 0.00164f
C9 w_n1578_n1909.n7 VSUBS 0.08814f
C10 w_n1578_n1909.t5 VSUBS 0.04407f
C11 w_n1578_n1909.n8 VSUBS 0.00164f
C12 w_n1578_n1909.n9 VSUBS 0.00227f
C13 w_n1578_n1909.n10 VSUBS 0.002f
C14 w_n1578_n1909.n11 VSUBS 0.002f
C15 w_n1578_n1909.n12 VSUBS 0
C16 w_n1578_n1909.n13 VSUBS 0.00318f
C17 w_n1578_n1909.n14 VSUBS 0.00227f
C18 w_n1578_n1909.n15 VSUBS 0.01264f
C19 w_n1578_n1909.n16 VSUBS 0.00227f
C20 w_n1578_n1909.n17 VSUBS 0.00227f
C21 w_n1578_n1909.t21 VSUBS 0.02351f
C22 w_n1578_n1909.n18 VSUBS 0.00227f
C23 w_n1578_n1909.n19 VSUBS 0.01264f
C24 w_n1578_n1909.n20 VSUBS 0.04221f
C25 w_n1578_n1909.n21 VSUBS 0.008f
C26 w_n1578_n1909.n22 VSUBS 0
C27 w_n1578_n1909.n23 VSUBS 0.00931f
C28 w_n1578_n1909.n24 VSUBS 0.01935f
C29 w_n1578_n1909.n25 VSUBS 0.00608f
C30 w_n1578_n1909.n26 VSUBS 0.00227f
C31 w_n1578_n1909.n27 VSUBS 0.01166f
C32 w_n1578_n1909.n28 VSUBS 0.00227f
C33 w_n1578_n1909.n29 VSUBS 0.01264f
C34 w_n1578_n1909.n30 VSUBS 0.00227f
C35 w_n1578_n1909.n31 VSUBS 0.00227f
C36 w_n1578_n1909.n32 VSUBS 0.01466f
C37 w_n1578_n1909.t12 VSUBS 0.02351f
C38 w_n1578_n1909.n33 VSUBS 0.01166f
C39 w_n1578_n1909.n34 VSUBS 0.00526f
C40 w_n1578_n1909.n35 VSUBS 0.01264f
C41 w_n1578_n1909.n36 VSUBS 0.01264f
C42 w_n1578_n1909.n37 VSUBS 0.00318f
C43 w_n1578_n1909.n38 VSUBS 0.01738f
C44 w_n1578_n1909.t10 VSUBS 0.00754f
C45 w_n1578_n1909.t19 VSUBS 0.00754f
C46 w_n1578_n1909.n39 VSUBS 0.00951f
C47 w_n1578_n1909.n40 VSUBS 0.01892f
C48 w_n1578_n1909.n42 VSUBS 0.00227f
C49 w_n1578_n1909.n43 VSUBS 0.00227f
C50 w_n1578_n1909.n44 VSUBS 0.00164f
C51 w_n1578_n1909.n45 VSUBS 0.00164f
C52 w_n1578_n1909.n46 VSUBS 0.05496f
C53 w_n1578_n1909.t11 VSUBS 0.02748f
C54 w_n1578_n1909.n47 VSUBS 0.00164f
C55 w_n1578_n1909.n48 VSUBS 0.00164f
C56 w_n1578_n1909.n49 VSUBS 0.00227f
C57 w_n1578_n1909.n50 VSUBS 0.00698f
C58 w_n1578_n1909.n51 VSUBS 0.00185f
C59 w_n1578_n1909.n52 VSUBS 0.008f
C60 w_n1578_n1909.t17 VSUBS 0.02748f
C61 w_n1578_n1909.n53 VSUBS 0.008f
C62 w_n1578_n1909.n54 VSUBS 0.00185f
C63 w_n1578_n1909.t16 VSUBS 0.00741f
C64 w_n1578_n1909.t18 VSUBS 0.04953f
C65 w_n1578_n1909.n55 VSUBS 0.03771f
C66 w_n1578_n1909.n56 VSUBS 0.05998f
C67 w_n1578_n1909.n58 VSUBS 0.091f
C68 w_n1578_n1909.n59 VSUBS 0.01937f
C69 w_n1578_n1909.n60 VSUBS 0.01453f
C70 w_n1578_n1909.n61 VSUBS 0.00552f
C71 w_n1578_n1909.n62 VSUBS 0.00227f
C72 w_n1578_n1909.n63 VSUBS 0.00227f
C73 w_n1578_n1909.n64 VSUBS 0.00164f
C74 w_n1578_n1909.n65 VSUBS 0.04088f
C75 w_n1578_n1909.n66 VSUBS 0.00164f
C76 w_n1578_n1909.n67 VSUBS 0.00227f
C77 w_n1578_n1909.n68 VSUBS 0.00227f
C78 w_n1578_n1909.n69 VSUBS 0.00227f
C79 w_n1578_n1909.n70 VSUBS 0.00227f
C80 w_n1578_n1909.n71 VSUBS 0.00227f
C81 w_n1578_n1909.n72 VSUBS 0.00227f
C82 w_n1578_n1909.n73 VSUBS 0.00227f
C83 w_n1578_n1909.n74 VSUBS 0.00164f
C84 w_n1578_n1909.n75 VSUBS 0.03332f
C85 w_n1578_n1909.n76 VSUBS 0.00227f
C86 w_n1578_n1909.n77 VSUBS 0.00164f
C87 w_n1578_n1909.n78 VSUBS 0.00164f
C88 w_n1578_n1909.n79 VSUBS 0.00164f
C89 w_n1578_n1909.n80 VSUBS 0.04088f
C90 w_n1578_n1909.n81 VSUBS 0.00164f
C91 w_n1578_n1909.n82 VSUBS 0.00227f
C92 w_n1578_n1909.n83 VSUBS 0.00227f
C93 w_n1578_n1909.n84 VSUBS 0.00227f
C94 w_n1578_n1909.n85 VSUBS 0.00698f
C95 w_n1578_n1909.n86 VSUBS 0.091f
C96 w_n1578_n1909.t14 VSUBS 0.02748f
C97 w_n1578_n1909.n87 VSUBS 0.00164f
C98 w_n1578_n1909.n88 VSUBS 0.00227f
C99 w_n1578_n1909.n89 VSUBS 0.00227f
C100 w_n1578_n1909.n90 VSUBS 0.00227f
C101 w_n1578_n1909.n91 VSUBS 0.00227f
C102 w_n1578_n1909.t13 VSUBS 0.00741f
C103 w_n1578_n1909.t15 VSUBS 0.04953f
C104 w_n1578_n1909.n92 VSUBS 0.03771f
C105 w_n1578_n1909.n93 VSUBS 0.01937f
C106 w_n1578_n1909.n94 VSUBS 0.01453f
C107 w_n1578_n1909.n95 VSUBS 0.00552f
C108 w_n1578_n1909.n96 VSUBS 0.00185f
C109 w_n1578_n1909.n97 VSUBS 0.008f
C110 w_n1578_n1909.n99 VSUBS 0.05998f
C111 w_n1578_n1909.n100 VSUBS 0.008f
C112 w_n1578_n1909.n101 VSUBS 0.00185f
C113 w_n1578_n1909.n102 VSUBS 0.00227f
C114 w_n1578_n1909.n103 VSUBS 0.00227f
C115 w_n1578_n1909.n104 VSUBS 0.00164f
C116 w_n1578_n1909.n105 VSUBS 0.05496f
C117 w_n1578_n1909.n106 VSUBS 0.04912f
C118 w_n1578_n1909.t20 VSUBS 0.02748f
C119 w_n1578_n1909.n107 VSUBS 0.03332f
C120 w_n1578_n1909.n108 VSUBS 0.00164f
C121 w_n1578_n1909.n109 VSUBS 0.00227f
C122 w_n1578_n1909.n110 VSUBS 0.00227f
C123 w_n1578_n1909.n111 VSUBS 0.00227f
C124 w_n1578_n1909.n112 VSUBS 0.00164f
C125 w_n1578_n1909.n113 VSUBS 0.04912f
C126 w_n1578_n1909.n114 VSUBS 0.00164f
C127 w_n1578_n1909.n115 VSUBS 0.00227f
C128 w_n1578_n1909.n117 VSUBS 0.03815f
C129 w_n1578_n1909.t3 VSUBS 0.00977f
C130 w_n1578_n1909.t1 VSUBS 0.00977f
C131 w_n1578_n1909.n120 VSUBS 0.06325f
C132 w_n1578_n1909.n121 VSUBS 0.00227f
C133 w_n1578_n1909.n122 VSUBS 0.00227f
C134 w_n1578_n1909.n123 VSUBS 0.00227f
C135 w_n1578_n1909.n124 VSUBS 0.00164f
C136 w_n1578_n1909.n125 VSUBS 0.00164f
C137 w_n1578_n1909.n126 VSUBS 0.06556f
C138 w_n1578_n1909.n127 VSUBS 0.00164f
C139 w_n1578_n1909.n128 VSUBS 0.00164f
C140 w_n1578_n1909.n129 VSUBS 0.00164f
C141 w_n1578_n1909.n130 VSUBS 0.05344f
C142 w_n1578_n1909.n131 VSUBS 0.00227f
C143 w_n1578_n1909.t0 VSUBS 0.04407f
C144 w_n1578_n1909.n132 VSUBS 0.00164f
C145 w_n1578_n1909.n133 VSUBS 0.00227f
C146 w_n1578_n1909.n134 VSUBS 0.00227f
C147 w_n1578_n1909.n135 VSUBS 0.00227f
C148 w_n1578_n1909.t7 VSUBS 0.00978f
C149 w_n1578_n1909.t9 VSUBS 0.07438f
C150 w_n1578_n1909.n136 VSUBS 0.04051f
C151 w_n1578_n1909.n137 VSUBS 0.01605f
C152 w_n1578_n1909.n138 VSUBS 0.00164f
C153 w_n1578_n1909.n139 VSUBS 0.24339f
C154 w_n1578_n1909.t8 VSUBS 0.04407f
C155 w_n1578_n1909.n140 VSUBS 0.0228f
C156 w_n1578_n1909.n141 VSUBS 0.00747f
C157 w_n1578_n1909.n142 VSUBS 0.00185f
C158 w_n1578_n1909.n143 VSUBS 0.00903f
C159 w_n1578_n1909.n144 VSUBS 0.09607f
C160 w_n1578_n1909.n146 VSUBS 0.00903f
C161 w_n1578_n1909.n147 VSUBS 0.00185f
C162 w_n1578_n1909.n148 VSUBS 0.00552f
C163 w_n1578_n1909.n149 VSUBS 0.00227f
C164 w_n1578_n1909.n150 VSUBS 0.00227f
C165 w_n1578_n1909.n151 VSUBS 0.00227f
C166 w_n1578_n1909.n152 VSUBS 0.00227f
C167 w_n1578_n1909.n153 VSUBS 0.00227f
C168 w_n1578_n1909.n154 VSUBS 0.00227f
C169 w_n1578_n1909.n155 VSUBS 0.00227f
C170 w_n1578_n1909.n156 VSUBS 0.00227f
C171 w_n1578_n1909.n157 VSUBS 0.00227f
C172 w_n1578_n1909.n158 VSUBS 0.00227f
C173 w_n1578_n1909.n159 VSUBS 0.00164f
C174 w_n1578_n1909.n160 VSUBS 0.07878f
C175 w_n1578_n1909.n161 VSUBS 0.00164f
C176 w_n1578_n1909.n162 VSUBS 0.00164f
C177 w_n1578_n1909.n163 VSUBS 0.00227f
C178 w_n1578_n1909.n164 VSUBS 0.00227f
C179 w_n1578_n1909.n165 VSUBS 0.00164f
C180 w_n1578_n1909.n166 VSUBS 0.05344f
C181 w_n1578_n1909.t2 VSUBS 0.04407f
C182 w_n1578_n1909.n167 VSUBS 0.07878f
C183 w_n1578_n1909.n168 VSUBS 0.08814f
C184 w_n1578_n1909.n169 VSUBS 0.00164f
C185 w_n1578_n1909.n170 VSUBS 0.00227f
C186 w_n1578_n1909.n171 VSUBS 0.002f
C187 w_n1578_n1909.n172 VSUBS 0.06256f
C188 w_n1578_n1909.n173 VSUBS 0.002f
C189 w_n1578_n1909.n174 VSUBS 0.00227f
C190 w_n1578_n1909.n175 VSUBS 0.00185f
C191 w_n1578_n1909.n176 VSUBS 0.00227f
C192 w_n1578_n1909.n177 VSUBS 0.00164f
C193 w_n1578_n1909.n178 VSUBS 0.06556f
C194 w_n1578_n1909.n179 VSUBS 0.00164f
C195 w_n1578_n1909.n180 VSUBS 0.00227f
C196 w_n1578_n1909.n181 VSUBS 0.00185f
C197 w_n1578_n1909.n182 VSUBS 0.00552f
C198 w_n1578_n1909.t4 VSUBS 0.00978f
C199 w_n1578_n1909.t6 VSUBS 0.07438f
C200 w_n1578_n1909.n183 VSUBS 0.04051f
C201 w_n1578_n1909.n184 VSUBS 0.01605f
C202 w_n1578_n1909.n185 VSUBS 0.0228f
C203 w_n1578_n1909.n186 VSUBS 0.01595f
C204 w_n1578_n1909.n187 VSUBS 0.1637f
C205 w_n1578_n1909.n188 VSUBS 0.06396f
C206 rf_amp_block_62479d0d_0/Unnamed_1f5ec66d_0/a_n142_n1189# VSUBS 0.13816f
.ends
