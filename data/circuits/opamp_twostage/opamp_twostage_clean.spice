.subckt OPAMP2 VIP VIM VO1 VX VTAIL VBIAS VDD VSS VOUT
XM1 VX  VIP VTAIL VSS nfet_03v3 w=4 l=0.5 m=2
XM2 VO1 VIM VTAIL VSS nfet_03v3 w=4 l=0.5 m=2
XM3 VX  VX  VDD   VDD pfet_03v3 w=8 l=0.5 m=2
XM4 VO1 VX  VDD   VDD pfet_03v3 w=8 l=0.5 m=2
XM5 VTAIL VBIAS VSS VSS nfet_03v3 w=8 l=0.5 m=2
XM6 VOUT VO1 VDD VDD pfet_03v3 w=12 l=0.5 m=2
XM7 VOUT VBIAS VSS VSS nfet_03v3 w=6 l=0.5 m=2
.ends OPAMP2
