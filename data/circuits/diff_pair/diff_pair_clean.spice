.subckt DIFF_PAIR VIP VIM VOP VOM VTAIL VSS
XM1 VOP VIP VTAIL VSS nfet_03v3 w=3 l=0.5 m=4
XM2 VOM VIM VTAIL VSS nfet_03v3 w=3 l=0.5 m=4
.ends DIFF_PAIR
