* NGSPICE file created from N_BLOCK.ext - technology: gf180mcuC

.subckt N_BLOCK
X0 a_n10260_n11526# a_n10260_n11526# a_n10260_n11526# a_n10260_n11526# nfet_03v3 ad=2.407p pd=9.46u as=0.2155n ps=0.85936m w=4.15u l=2u
X1 a_n10260_n11526# a_n10260_n11526# a_n10260_n11526# a_n10260_n11526# nfet_03v3 ad=2.32p pd=9.16u as=0 ps=0 w=4u l=2u
X2 a_n10260_n11526# a_n10260_n11526# a_n10260_n11526# a_n10260_n11526# nfet_03v3 ad=1.595p pd=6.66u as=0 ps=0 w=2.75u l=1u
X3 a_n985_n7641# a_n985_n7641# a_n10260_n11526# a_n10260_n11526# nfet_03v3 ad=1.35p pd=5.7u as=1.35p ps=5.7u w=2.25u l=1u
X4 a_n10260_n11526# a_1330_n909# a_n10260_n11526# a_n10260_n11526# nfet_03v3 ad=2.4p pd=9.2u as=0 ps=0 w=4u l=2u
X5 a_n10260_n11526# a_n10260_n11526# a_n10260_n11526# a_n10260_n11526# nfet_03v3 ad=1.595p pd=6.66u as=0 ps=0 w=2.75u l=1u
X6 a_n10260_n11526# a_n10260_n11526# a_n10260_n11526# a_n10260_n11526# nfet_03v3 ad=1.65p pd=6.7u as=0 ps=0 w=2.75u l=1u
X7 a_n9206_n11072# a_n5614_n11321# a_n10260_n11526# a_n10260_n11526# nfet_03v3 ad=1.162p pd=4.71u as=2.49p ps=9.5u w=4.15u l=2u
X8 a_n10260_n11526# a_n10260_n11526# a_n10260_n11526# a_n10260_n11526# nfet_03v3 ad=2.407p pd=9.46u as=0 ps=0 w=4.15u l=2u
X9 a_n10260_n11526# a_n10260_n11526# a_n10260_n11526# a_n10260_n11526# nfet_03v3 ad=2.407p pd=9.46u as=0 ps=0 w=4.15u l=2u
X10 a_n576_n14953# a_n9086_n11321# a_n9086_n11321# a_n10260_n11526# nfet_03v3 ad=2.49p pd=9.5u as=1.162p ps=4.71u w=4.15u l=2u
X11 a_n10260_n11526# a_n5724_n1573# a_n10260_n11526# a_n10260_n11526# nfet_03v3 ad=2.4p pd=9.2u as=0 ps=0 w=4u l=2u
X12 a_n10260_n11526# a_n10260_n11526# a_n10260_n11526# a_n10260_n11526# nfet_03v3 ad=1.595p pd=6.66u as=0 ps=0 w=2.75u l=1u
X13 a_n9206_n11072# a_n9086_n11321# a_n8686_n11072# a_n10260_n11526# nfet_03v3 ad=2.49p pd=9.5u as=1.162p ps=4.71u w=4.15u l=2u
X14 a_n10260_n11526# a_n10260_n11526# a_n10260_n11526# a_n10260_n11526# nfet_03v3 ad=2.407p pd=9.46u as=0 ps=0 w=4.15u l=2u
X15 a_n10260_n11526# a_n10260_n11526# a_n10260_n11526# a_n10260_n11526# nfet_03v3 ad=0.8236p pd=4u as=0 ps=0 w=1.42u l=2u
X16 a_n10260_n11526# a_n10260_n11526# a_n10260_n11526# a_n10260_n11526# nfet_03v3 ad=1.595p pd=6.66u as=0 ps=0 w=2.75u l=1u
X17 a_n10260_n11526# a_1330_n909# a_n10260_n11526# a_n10260_n11526# nfet_03v3 ad=2.4p pd=9.2u as=0 ps=0 w=4u l=2u
X18 a_n10260_n11526# a_n10260_n11526# a_n10260_n11526# a_n10260_n11526# nfet_03v3 ad=1.65p pd=6.7u as=0 ps=0 w=2.75u l=1u
X19 a_n985_n7641# a_n985_n7641# a_n10260_n11526# a_n10260_n11526# nfet_03v3 ad=1.35p pd=5.7u as=1.35p ps=5.7u w=2.25u l=1u
X20 a_n10260_n11526# a_n10260_n11526# a_n10260_n11526# a_n10260_n11526# nfet_03v3 ad=2.407p pd=9.46u as=0 ps=0 w=4.15u l=2u
X21 a_n10260_n11526# a_n10260_n11526# a_n10260_n11526# a_n10260_n11526# nfet_03v3 ad=2.407p pd=9.46u as=0 ps=0 w=4.15u l=2u
X22 a_n10260_n11526# a_n10260_n11526# a_n10260_n11526# a_n10260_n11526# nfet_03v3 ad=1.595p pd=6.66u as=0 ps=0 w=2.75u l=1u
X23 a_n10260_n11526# a_n10260_n11526# a_n10260_n11526# a_n10260_n11526# nfet_03v3 ad=2.32p pd=9.16u as=0 ps=0 w=4u l=2u
X24 a_n10260_n11526# a_n10260_n11526# a_n10260_n11526# a_n10260_n11526# nfet_03v3 ad=1.595p pd=6.66u as=0 ps=0 w=2.75u l=1u
X25 a_n10260_n11526# a_n10260_n11526# a_n10260_n11526# a_n10260_n11526# nfet_03v3 ad=2.407p pd=9.46u as=0 ps=0 w=4.15u l=2u
X26 a_n195_n7140# a_n985_n7641# a_n10260_n11526# a_n10260_n11526# nfet_03v3 ad=1.35p pd=5.7u as=1.35p ps=5.7u w=2.25u l=1u
X27 a_n9086_n11321# a_n9086_n11321# a_n576_n14953# a_n10260_n11526# nfet_03v3 ad=1.162p pd=4.71u as=2.49p ps=9.5u w=4.15u l=2u
X28 a_n10260_n11526# a_n10260_n11526# a_n10260_n11526# a_n10260_n11526# nfet_03v3 ad=2.407p pd=9.46u as=0 ps=0 w=4.15u l=2u
X29 a_n10260_n11526# a_n10260_n11526# a_n10260_n11526# a_n10260_n11526# nfet_03v3 ad=0.8236p pd=4u as=0 ps=0 w=1.42u l=2u
X30 a_n10260_n11526# a_n10260_n11526# a_n10260_n11526# a_n10260_n11526# nfet_03v3 ad=2.32p pd=9.16u as=0 ps=0 w=4u l=2u
X31 a_n10260_n11526# a_n10260_n11526# a_n10260_n11526# a_n10260_n11526# nfet_03v3 ad=2.32p pd=9.16u as=0 ps=0 w=4u l=2u
X32 a_n10260_n11526# a_n10260_n11526# a_n10260_n11526# a_n10260_n11526# nfet_03v3 ad=2.407p pd=9.46u as=0 ps=0 w=4.15u l=2u
X33 a_n10260_n11526# a_n10260_n11526# a_n10260_n11526# a_n10260_n11526# nfet_03v3 ad=2.407p pd=9.46u as=0 ps=0 w=4.15u l=2u
X34 a_n2262_n11072# a_n5614_n11321# a_n10260_n11526# a_n10260_n11526# nfet_03v3 ad=1.162p pd=4.71u as=2.49p ps=9.5u w=4.15u l=2u
X35 a_n10260_n11526# a_n10260_n11526# a_n10260_n11526# a_n10260_n11526# nfet_03v3 ad=1.595p pd=6.66u as=0 ps=0 w=2.75u l=1u
X36 a_n10260_n11526# a_n10260_n11526# a_n10260_n11526# a_n10260_n11526# nfet_03v3 ad=2.32p pd=9.16u as=0 ps=0 w=4u l=2u
X37 a_n10260_n11526# a_n10260_n11526# a_n10260_n11526# a_n10260_n11526# nfet_03v3 ad=2.32p pd=9.16u as=0 ps=0 w=4u l=2u
X38 a_n10260_n11526# a_n10260_n11526# a_n10260_n11526# a_n10260_n11526# nfet_03v3 ad=1.305p pd=5.66u as=0 ps=0 w=2.25u l=1u
X39 a_n10260_n11526# a_n5614_n11321# a_5102_n11072# a_n10260_n11526# nfet_03v3 ad=2.49p pd=9.5u as=1.162p ps=4.71u w=4.15u l=2u
X40 a_n10260_n11526# a_n10260_n11526# a_n10260_n11526# a_n10260_n11526# nfet_03v3 ad=2.32p pd=9.16u as=0 ps=0 w=4u l=2u
X41 a_n10260_n11526# a_n10260_n11526# a_n10260_n11526# a_n10260_n11526# nfet_03v3 ad=2.407p pd=9.46u as=0 ps=0 w=4.15u l=2u
X42 a_n10260_n11526# a_n10260_n11526# a_n10260_n11526# a_n10260_n11526# nfet_03v3 ad=1.65p pd=6.7u as=0 ps=0 w=2.75u l=1u
X43 a_n10260_n11526# a_n10260_n11526# a_n10260_n11526# a_n10260_n11526# nfet_03v3 ad=2.32p pd=9.16u as=0 ps=0 w=4u l=2u
X44 a_8574_n11072# a_n9086_n11321# a_5102_n11072# a_n10260_n11526# nfet_03v3 ad=1.162p pd=4.71u as=2.49p ps=9.5u w=4.15u l=2u
X45 a_n10260_n11526# a_n10260_n11526# a_n10260_n11526# a_n10260_n11526# nfet_03v3 ad=2.32p pd=9.16u as=0 ps=0 w=4u l=2u
X46 a_n10260_n11526# a_n10260_n11526# a_n10260_n11526# a_n10260_n11526# nfet_03v3 ad=2.32p pd=9.16u as=0 ps=0 w=4u l=2u
X47 a_n10260_n11526# a_n10260_n11526# a_n10260_n11526# a_n10260_n11526# nfet_03v3 ad=2.407p pd=9.46u as=0 ps=0 w=4.15u l=2u
X48 a_n576_n14953# a_n9086_n11321# a_n10260_n11526# a_n10260_n11526# nfet_03v3 ad=0.852p pd=4.04u as=0.852p ps=4.04u w=1.42u l=2u
X49 a_n10260_n11526# a_n10260_n11526# a_n10260_n11526# a_n10260_n11526# nfet_03v3 ad=2.407p pd=9.46u as=0 ps=0 w=4.15u l=2u
X50 a_n2262_n11072# a_n9086_n11321# a_n5614_n11321# a_n10260_n11526# nfet_03v3 ad=2.49p pd=9.5u as=1.162p ps=4.71u w=4.15u l=2u
X51 a_n10260_n11526# a_n5724_n1573# a_n10260_n11526# a_n10260_n11526# nfet_03v3 ad=2.4p pd=9.2u as=0 ps=0 w=4u l=2u
X52 a_n10260_n11526# a_n10260_n11526# a_n10260_n11526# a_n10260_n11526# nfet_03v3 ad=1.65p pd=6.7u as=0 ps=0 w=2.75u l=1u
X53 a_n10260_n11526# a_n10260_n11526# a_n10260_n11526# a_n10260_n11526# nfet_03v3 ad=1.595p pd=6.66u as=0 ps=0 w=2.75u l=1u
X54 a_n10260_n11526# a_n5614_n11321# a_n9206_n11072# a_n10260_n11526# nfet_03v3 ad=2.49p pd=9.5u as=1.162p ps=4.71u w=4.15u l=2u
X55 a_n5614_n11321# a_n9086_n11321# a_n2262_n11072# a_n10260_n11526# nfet_03v3 ad=1.162p pd=4.71u as=2.49p ps=9.5u w=4.15u l=2u
X56 a_5102_n11072# a_n5614_n11321# a_n10260_n11526# a_n10260_n11526# nfet_03v3 ad=1.162p pd=4.71u as=2.49p ps=9.5u w=4.15u l=2u
X57 a_n10260_n11526# a_n10260_n11526# a_n10260_n11526# a_n10260_n11526# nfet_03v3 ad=1.305p pd=5.66u as=0 ps=0 w=2.25u l=1u
X58 a_n10260_n11526# a_n5614_n11321# a_n2262_n11072# a_n10260_n11526# nfet_03v3 ad=2.49p pd=9.5u as=1.162p ps=4.71u w=4.15u l=2u
X59 a_n10260_n11526# a_n10260_n11526# a_n10260_n11526# a_n10260_n11526# nfet_03v3 ad=2.32p pd=9.16u as=0 ps=0 w=4u l=2u
X60 a_n8686_n11072# a_n9086_n11321# a_n9206_n11072# a_n10260_n11526# nfet_03v3 ad=1.162p pd=4.71u as=2.49p ps=9.5u w=4.15u l=2u
X61 a_n1330_n661# a_n5724_n1573# a_n10260_n11526# a_n10260_n11526# nfet_03v3 ad=2.4p pd=9.2u as=2.4p ps=9.2u w=4u l=2u
X62 a_1730_n661# a_1330_n909# a_n10260_n11526# a_n10260_n11526# nfet_03v3 ad=2.4p pd=9.2u as=2.4p ps=9.2u w=4u l=2u
X63 a_n195_n7140# a_n985_n7641# a_n10260_n11526# a_n10260_n11526# nfet_03v3 ad=1.35p pd=5.7u as=1.35p ps=5.7u w=2.25u l=1u
X64 a_n10260_n11526# a_n10260_n11526# a_n10260_n11526# a_n10260_n11526# nfet_03v3 ad=2.32p pd=9.16u as=0 ps=0 w=4u l=2u
X65 a_5102_n11072# a_n9086_n11321# a_8574_n11072# a_n10260_n11526# nfet_03v3 ad=2.49p pd=9.5u as=1.162p ps=4.71u w=4.15u l=2u
X66 a_n10260_n11526# a_n10260_n11526# a_n10260_n11526# a_n10260_n11526# nfet_03v3 ad=2.407p pd=9.46u as=0 ps=0 w=4.15u l=2u
C0 a_n985_n7641# a_n2262_n11072# 0.00345f
C1 a_n9086_n11321# a_n9206_n11072# 0.5701f
C2 a_n576_n14953# a_n9086_n11321# 2.23166f
C3 a_1330_n909# a_1730_n661# 0.22944f
C4 a_n5614_n11321# a_n2262_n11072# 1.44058f
C5 a_n5614_n11321# a_n9086_n11321# 6.33817f
C6 a_5102_n11072# a_n5614_n11321# 0.47781f
C7 a_n1330_n661# a_n5724_n1573# 0.20161f
C8 a_n8686_n11072# a_n9206_n11072# 0.95874f
C9 a_n2262_n11072# a_n9086_n11321# 0.57173f
C10 a_n985_n7641# a_n195_n7140# 0.50261f
C11 a_5102_n11072# a_n9086_n11321# 0.5701f
C12 a_8574_n11072# a_n9086_n11321# 0.47247f
C13 a_n5614_n11321# a_n9206_n11072# 0.48159f
C14 a_5102_n11072# a_8574_n11072# 0.96303f
C15 a_n5614_n11321# a_n576_n14953# 0.22827f
C16 a_n8686_n11072# a_n9086_n11321# 0.47247f
C17 a_n576_n14953# a_n10260_n11526# 4.03086f
C18 a_8574_n11072# a_n10260_n11526# 0.62395f
C19 a_5102_n11072# a_n10260_n11526# 4.64548f
C20 a_n2262_n11072# a_n10260_n11526# 4.51465f
C21 a_n5614_n11321# a_n10260_n11526# 15.7218f
C22 a_n8686_n11072# a_n10260_n11526# 0.62395f
C23 a_n9206_n11072# a_n10260_n11526# 4.64504f
C24 a_n9086_n11321# a_n10260_n11526# 26.6155f
C25 a_n195_n7140# a_n10260_n11526# 5.34653f
C26 a_n985_n7641# a_n10260_n11526# 10.8746f
C27 a_1730_n661# a_n10260_n11526# 1.6871f
C28 a_1330_n909# a_n10260_n11526# 9.27947f
C29 a_n1330_n661# a_n10260_n11526# 1.6843f
C30 a_n5724_n1573# a_n10260_n11526# 9.30696f
.ends
