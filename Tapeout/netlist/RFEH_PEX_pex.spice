* NGSPICE file created from RFEH_PEX.ext - technology: gf180mcuD

.subckt RFEH_PEX VRECT RFP RFN VSS VOUT N1 N2 VMID1 VMID2
X0 VSS.t53 RFP.t5 RFN.t2 VSS.t52 nfet_03v3 ad=2.25p pd=7.5u as=2.25p ps=7.5u w=3u l=0.28u
X1 VSS.t29 VSS.t27 VSS.t29 VSS.t28 nfet_03v3 ad=2.19p pd=7.46u as=0 ps=0 w=3u l=0.28u
X2 VRECT.t25 RFP.t7 RFN.t0 VRECT.t24 pfet_03v3 ad=3.75p pd=11.5u as=3.75p ps=11.5u w=5u l=0.28u
X3 VRECT.t9 VRECT.t7 VRECT.t9 VRECT.t8 pfet_03v3 ad=3.65p pd=11.46u as=0 ps=0 w=5u l=0.28u
X4 VSS.t35 VSS.t33 VSS.t35 VSS.t34 nfet_03v3 ad=1.16p pd=5.16u as=0 ps=0 w=2u l=1u
X5 VMID2.t3 VMID2.t2 VRECT.t3 VRECT.t2 pfet_03v3 ad=2.4p pd=9.2u as=2.4p ps=9.2u w=4u l=1u
X6 VSS.t55 RFP.t4 RFN.t3 VSS.t54 nfet_03v3 ad=2.25p pd=7.5u as=2.25p ps=7.5u w=3u l=0.28u
X7 VMID2.t1 VMID2.t0 VSS.t39 VSS.t38 nfet_03v3 ad=1.2p pd=5.2u as=1.2p ps=5.2u w=2u l=1u
X8 VSS.t2 VSS.t0 VSS.t2 VSS.t1 nfet_03v3 ad=2.92p pd=9.46u as=0 ps=0 w=4u l=0.28u
X9 VSS.t17 VSS.t15 VSS.t17 VSS.t16 nfet_03v3 ad=2.92p pd=9.46u as=0 ps=0 w=4u l=0.28u
X10 VSS.t5 VSS.t3 VSS.t5 VSS.t4 nfet_03v3 ad=2.92p pd=9.46u as=0 ps=0 w=4u l=0.28u
X11 VRECT.t27 RFP.t6 RFN.t1 VRECT.t26 pfet_03v3 ad=3.75p pd=11.5u as=3.75p ps=11.5u w=5u l=0.28u
X12 VMID1.t5 VMID1.t4 VRECT.t21 VRECT.t20 pfet_03v3 ad=2.4p pd=9.2u as=2.4p ps=9.2u w=4u l=1u
X13 VOUT.t0 N2.t4 N2.t5 VSS.t43 nfet_03v3 ad=3p pd=9.5u as=1.72p ps=4.86u w=4u l=0.28u
X14 N1.t1 N1.t0 N2.t1 VSS.t36 nfet_03v3 ad=1.72p pd=4.86u as=3p ps=9.5u w=4u l=0.28u
X15 N2.t0 N1.t2 N1.t3 VSS.t37 nfet_03v3 ad=3p pd=9.5u as=1.72p ps=4.86u w=4u l=0.28u
X16 VMID2.t7 VMID2.t6 VSS.t41 VSS.t40 nfet_03v3 ad=1.2p pd=5.2u as=1.2p ps=5.2u w=2u l=1u
X17 N1.t4 VRECT.t18 VRECT.t19 VSS.t45 nfet_03v3 ad=3p pd=9.5u as=1.72p ps=4.86u w=4u l=0.28u
X18 VRECT.t12 VRECT.t10 VRECT.t12 VRECT.t11 pfet_03v3 ad=2.32p pd=9.16u as=0 ps=0 w=4u l=1u
X19 VMID1.t1 VMID1.t0 VRECT.t23 VRECT.t22 pfet_03v3 ad=2.4p pd=9.2u as=2.4p ps=9.2u w=4u l=1u
X20 VMID1.t3 VMID1.t2 VSS.t49 VSS.t48 nfet_03v3 ad=1.2p pd=5.2u as=1.2p ps=5.2u w=2u l=1u
X21 VSS.t57 RFN.t5 RFP.t1 VSS.t56 nfet_03v3 ad=2.25p pd=7.5u as=2.25p ps=7.5u w=3u l=0.28u
X22 VSS.t8 VSS.t6 VSS.t8 VSS.t7 nfet_03v3 ad=2.92p pd=9.46u as=0 ps=0 w=4u l=0.28u
X23 N2.t3 N2.t2 VOUT.t1 VSS.t42 nfet_03v3 ad=1.72p pd=4.86u as=3p ps=9.5u w=4u l=0.28u
X24 VSS.t23 VSS.t21 VSS.t23 VSS.t22 nfet_03v3 ad=0.58p pd=3.16u as=0 ps=0 w=1u l=10u
X25 VRECT.t29 RFN.t7 RFP.t3 VRECT.t28 pfet_03v3 ad=3.75p pd=11.5u as=3.75p ps=11.5u w=5u l=0.28u
X26 VSS.t32 VSS.t30 VSS.t32 VSS.t31 nfet_03v3 ad=1.16p pd=5.16u as=0 ps=0 w=2u l=1u
X27 VRECT.t17 VRECT.t16 N1.t5 VSS.t44 nfet_03v3 ad=1.72p pd=4.86u as=3p ps=9.5u w=4u l=0.28u
X28 VOUT.t3 VOUT.t2 VSS.t47 VSS.t46 nfet_03v3 ad=0.6p pd=3.2u as=0.6p ps=3.2u w=1u l=10u
X29 VSS.t26 VSS.t24 VSS.t26 VSS.t25 nfet_03v3 ad=2.19p pd=7.46u as=0 ps=0 w=3u l=0.28u
X30 VSS.t59 RFN.t4 RFP.t2 VSS.t58 nfet_03v3 ad=2.25p pd=7.5u as=2.25p ps=7.5u w=3u l=0.28u
X31 VSS.t20 VSS.t18 VSS.t20 VSS.t19 nfet_03v3 ad=0.58p pd=3.16u as=0 ps=0 w=1u l=10u
X32 VRECT.t15 VRECT.t13 VRECT.t15 VRECT.t14 pfet_03v3 ad=2.32p pd=9.16u as=0 ps=0 w=4u l=1u
X33 VMID1.t7 VMID1.t6 VSS.t51 VSS.t50 nfet_03v3 ad=1.2p pd=5.2u as=1.2p ps=5.2u w=2u l=1u
X34 VRECT.t6 VRECT.t4 VRECT.t6 VRECT.t5 pfet_03v3 ad=3.65p pd=11.46u as=0 ps=0 w=5u l=0.28u
X35 VRECT.t31 RFN.t6 RFP.t0 VRECT.t30 pfet_03v3 ad=3.75p pd=11.5u as=3.75p ps=11.5u w=5u l=0.28u
X36 VMID2.t5 VMID2.t4 VRECT.t1 VRECT.t0 pfet_03v3 ad=2.4p pd=9.2u as=2.4p ps=9.2u w=4u l=1u
X37 VSS.t11 VSS.t9 VSS.t11 VSS.t10 nfet_03v3 ad=2.92p pd=9.46u as=0 ps=0 w=4u l=0.28u
X38 VSS.t14 VSS.t12 VSS.t14 VSS.t13 nfet_03v3 ad=2.92p pd=9.46u as=0 ps=0 w=4u l=0.28u
R0 VOUT VOUT.n0 38.9405
R1 VOUT VOUT.t2 15.5454
R2 VOUT VOUT.t3 12.9675
R3 VOUT.n0 VOUT.t1 6.94103
R4 VOUT VOUT.t0 6.59363
R5 VOUT.n0 VOUT 0.0635
R6 N2.n0 N2.t4 74.5439
R7 N2.n0 N2.t2 74.5439
R8 N2.n2 N2.n0 23.4211
R9 N2.n3 N2.n2 19.3169
R10 N2.n3 N2.t1 6.86903
R11 N2 N2.t0 6.59363
R12 N2.n2 N2.n1 6.0729
R13 N2.n1 N2.t5 0.67775
R14 N2.n1 N2.t3 0.67775
R15 N2 N2.n3 0.1355
R16 N1.n0 N1.t2 74.5439
R17 N1.n0 N1.t0 74.5439
R18 N1.n2 N1.n0 23.4211
R19 N1.n3 N1.n2 19.3169
R20 N1.n3 N1.t5 6.86903
R21 N1 N1.t4 6.59363
R22 N1.n2 N1.n1 6.0729
R23 N1.n1 N1.t3 0.67775
R24 N1.n1 N1.t1 0.67775
R25 N1 N1.n3 0.1355
R26 VMID2.n3 VMID2.t2 41.5897
R27 VMID2.n3 VMID2.t4 41.4133
R28 VMID2.n0 VMID2.t6 34.2167
R29 VMID2.n0 VMID2.t0 34.0403
R30 VMID2.n1 VMID2.t7 9.1578
R31 VMID2.n1 VMID2.t1 8.7006
R32 VMID2.n5 VMID2.t3 7.58601
R33 VMID2.n5 VMID2.t5 7.12881
R34 VMID2.n2 VMID2.n0 5.36
R35 VMID2.n2 VMID2.n1 4.5005
R36 VMID2.n4 VMID2.n3 4.5005
R37 VMID2.n6 VMID2.n5 4.5005
R38 VMID2.n4 VMID2.n2 1.20425
R39 VMID2.n6 VMID2.n4 1.08613
R40 VMID2 VMID2.n6 0.006125
R41 VMID1.n3 VMID1.t4 33.4867
R42 VMID1.n3 VMID1.t0 33.3103
R43 VMID1.n0 VMID1.t2 26.1867
R44 VMID1.n0 VMID1.t6 26.0103
R45 VMID1.n1 VMID1.t7 8.56075
R46 VMID1.n1 VMID1.t3 8.45635
R47 VMID1.n5 VMID1.t1 6.98896
R48 VMID1.n5 VMID1.t5 6.88456
R49 VMID1.n2 VMID1.n0 4.99438
R50 VMID1.n2 VMID1.n1 4.5005
R51 VMID1.n4 VMID1.n3 4.5005
R52 VMID1.n6 VMID1.n5 4.5005
R53 VMID1.n4 VMID1.n2 1.571
R54 VMID1.n6 VMID1.n4 0.719375
R55 VMID1 VMID1.n6 0.006125
R56 RFP.n4 RFP.t6 125.175
R57 RFP.n4 RFP.t7 124.428
R58 RFP.n0 RFP.t4 98.8437
R59 RFP.n0 RFP.t5 98.0967
R60 RFP.n1 RFP 19.1922
R61 RFP.n2 RFP.t1 7.73213
R62 RFP.n2 RFP.t2 7.36313
R63 RFP.n6 RFP.t3 6.92192
R64 RFP.n6 RFP.t0 6.55292
R65 RFP.n1 RFP.n0 4.5005
R66 RFP.n3 RFP.n2 4.5005
R67 RFP.n5 RFP.n4 4.5005
R68 RFP.n7 RFP.n6 4.5005
R69 RFP.n5 RFP.n3 1.53612
R70 RFP.n7 RFP.n5 0.86675
R71 RFP.n3 RFP.n1 0.640625
R72 RFP RFP.n7 0.006125
R73 RFN.n4 RFN.t7 96.2365
R74 RFN.n4 RFN.t6 95.4895
R75 RFN.n0 RFN.t5 70.1651
R76 RFN.n0 RFN.t4 69.4181
R77 RFN.n1 RFN 20.8482
R78 RFN.n2 RFN.t2 7.98898
R79 RFN.n2 RFN.t3 7.94758
R80 RFN.n6 RFN.t0 7.17877
R81 RFN.n6 RFN.t1 7.13737
R82 RFN.n1 RFN.n0 4.5005
R83 RFN.n3 RFN.n2 4.5005
R84 RFN.n5 RFN.n4 4.5005
R85 RFN.n7 RFN.n6 4.5005
R86 RFN.n5 RFN.n3 1.41912
R87 RFN.n7 RFN.n5 0.98375
R88 RFN.n3 RFN.n1 0.75875
R89 RFN RFN.n7 0.006125
R90 VRECT.n224 VRECT.n218 129.326
R91 VRECT.n294 VRECT.n176 129.326
R92 VRECT.n68 VRECT.n62 121.626
R93 VRECT.n151 VRECT.n13 121.626
R94 VRECT.n174 VRECT.t4 83.1425
R95 VRECT.n221 VRECT.t7 83.1425
R96 VRECT.n0 VRECT.t18 74.5439
R97 VRECT.n0 VRECT.t16 74.5439
R98 VRECT.n74 VRECT.n56 64.7778
R99 VRECT.n83 VRECT.n56 64.7778
R100 VRECT.n83 VRECT.n82 64.7778
R101 VRECT.n91 VRECT.n44 64.7778
R102 VRECT.n101 VRECT.n44 64.7778
R103 VRECT.n101 VRECT.n100 64.7778
R104 VRECT.n109 VRECT.n33 64.7778
R105 VRECT.n119 VRECT.n33 64.7778
R106 VRECT.n118 VRECT.n24 64.7778
R107 VRECT.n128 VRECT.n24 64.7778
R108 VRECT.n128 VRECT.n25 64.7778
R109 VRECT.n137 VRECT.n136 64.7778
R110 VRECT.n139 VRECT.n137 64.7778
R111 VRECT.n139 VRECT.n138 64.7778
R112 VRECT.n231 VRECT.n213 59.9256
R113 VRECT.n239 VRECT.n213 59.9256
R114 VRECT.n250 VRECT.n206 59.9256
R115 VRECT.n250 VRECT.n249 59.9256
R116 VRECT.n258 VRECT.n192 59.9256
R117 VRECT.n271 VRECT.n192 59.9256
R118 VRECT.n271 VRECT.n270 59.9256
R119 VRECT.n269 VRECT.n185 59.9256
R120 VRECT.n281 VRECT.n185 59.9256
R121 VRECT.n282 VRECT.n178 59.9256
R122 VRECT.n291 VRECT.n178 59.9256
R123 VRECT.n149 VRECT.n13 57.5413
R124 VRECT.n68 VRECT.n67 57.5413
R125 VRECT.n294 VRECT.n293 55.439
R126 VRECT.n224 VRECT.n223 55.439
R127 VRECT.n249 VRECT.t30 55.0567
R128 VRECT.t24 VRECT.n269 55.0567
R129 VRECT.n109 VRECT.t22 54.6564
R130 VRECT.n119 VRECT.t0 54.6564
R131 VRECT.n239 VRECT.t26 45.3189
R132 VRECT.n282 VRECT.t28 45.3189
R133 VRECT.n66 VRECT.t14 43.3203
R134 VRECT.n150 VRECT.t11 43.3203
R135 VRECT.n166 VRECT.n3 42.9668
R136 VRECT.n91 VRECT.t2 34.4135
R137 VRECT.n25 VRECT.t20 34.4135
R138 VRECT.n231 VRECT.t8 31.0866
R139 VRECT.t5 VRECT.n291 31.0866
R140 VRECT.n82 VRECT.t2 30.3649
R141 VRECT.n136 VRECT.t20 30.3649
R142 VRECT.n144 VRECT.t10 29.2196
R143 VRECT.n64 VRECT.t13 29.2196
R144 VRECT.n222 VRECT.t8 28.8395
R145 VRECT.n292 VRECT.t5 28.8395
R146 VRECT.n2 VRECT.n0 23.4211
R147 VRECT.n74 VRECT.t14 21.458
R148 VRECT.n138 VRECT.t11 21.458
R149 VRECT.t26 VRECT.n206 14.6072
R150 VRECT.t28 VRECT.n281 14.6072
R151 VRECT.n73 VRECT.n62 14.0005
R152 VRECT.n73 VRECT.n55 14.0005
R153 VRECT.n84 VRECT.n55 14.0005
R154 VRECT.n84 VRECT.n51 14.0005
R155 VRECT.n90 VRECT.n51 14.0005
R156 VRECT.n90 VRECT.n43 14.0005
R157 VRECT.n102 VRECT.n43 14.0005
R158 VRECT.n102 VRECT.n39 14.0005
R159 VRECT.n108 VRECT.n39 14.0005
R160 VRECT.n108 VRECT.n31 14.0005
R161 VRECT.n120 VRECT.n31 14.0005
R162 VRECT.n120 VRECT.n32 14.0005
R163 VRECT.n32 VRECT.n26 14.0005
R164 VRECT.n127 VRECT.n26 14.0005
R165 VRECT.n127 VRECT.n27 14.0005
R166 VRECT.n27 VRECT.n7 14.0005
R167 VRECT.n8 VRECT.n7 14.0005
R168 VRECT.n9 VRECT.n8 14.0005
R169 VRECT.n12 VRECT.n9 14.0005
R170 VRECT.n151 VRECT.n12 14.0005
R171 VRECT.n75 VRECT.n61 14.0005
R172 VRECT.n75 VRECT.n57 14.0005
R173 VRECT.n81 VRECT.n57 14.0005
R174 VRECT.n81 VRECT.n50 14.0005
R175 VRECT.n92 VRECT.n50 14.0005
R176 VRECT.n92 VRECT.n45 14.0005
R177 VRECT.n99 VRECT.n45 14.0005
R178 VRECT.n99 VRECT.n38 14.0005
R179 VRECT.n110 VRECT.n38 14.0005
R180 VRECT.n111 VRECT.n110 14.0005
R181 VRECT.n111 VRECT.n34 14.0005
R182 VRECT.n117 VRECT.n34 14.0005
R183 VRECT.n117 VRECT.n23 14.0005
R184 VRECT.n129 VRECT.n23 14.0005
R185 VRECT.n129 VRECT.n19 14.0005
R186 VRECT.n135 VRECT.n19 14.0005
R187 VRECT.n135 VRECT.n18 14.0005
R188 VRECT.n140 VRECT.n18 14.0005
R189 VRECT.n140 VRECT.n14 14.0005
R190 VRECT.n148 VRECT.n14 14.0005
R191 VRECT.n232 VRECT.n218 14.0005
R192 VRECT.n232 VRECT.n214 14.0005
R193 VRECT.n238 VRECT.n214 14.0005
R194 VRECT.n238 VRECT.n205 14.0005
R195 VRECT.n251 VRECT.n205 14.0005
R196 VRECT.n251 VRECT.n201 14.0005
R197 VRECT.n257 VRECT.n201 14.0005
R198 VRECT.n257 VRECT.n190 14.0005
R199 VRECT.n272 VRECT.n190 14.0005
R200 VRECT.n272 VRECT.n191 14.0005
R201 VRECT.n191 VRECT.n186 14.0005
R202 VRECT.n279 VRECT.n186 14.0005
R203 VRECT.n280 VRECT.n279 14.0005
R204 VRECT.n280 VRECT.n170 14.0005
R205 VRECT.n171 VRECT.n170 14.0005
R206 VRECT.n172 VRECT.n171 14.0005
R207 VRECT.n176 VRECT.n172 14.0005
R208 VRECT.n230 VRECT.n219 14.0005
R209 VRECT.n230 VRECT.n212 14.0005
R210 VRECT.n240 VRECT.n212 14.0005
R211 VRECT.n240 VRECT.n207 14.0005
R212 VRECT.n248 VRECT.n207 14.0005
R213 VRECT.n248 VRECT.n200 14.0005
R214 VRECT.n259 VRECT.n200 14.0005
R215 VRECT.n260 VRECT.n259 14.0005
R216 VRECT.n260 VRECT.n193 14.0005
R217 VRECT.n194 VRECT.n193 14.0005
R218 VRECT.n268 VRECT.n194 14.0005
R219 VRECT.n268 VRECT.n195 14.0005
R220 VRECT.n195 VRECT.n184 14.0005
R221 VRECT.n283 VRECT.n184 14.0005
R222 VRECT.n283 VRECT.n179 14.0005
R223 VRECT.n290 VRECT.n179 14.0005
R224 VRECT.n290 VRECT.n177 14.0005
R225 VRECT.n308 VRECT.n307 11.3456
R226 VRECT.n166 VRECT.n165 11.1431
R227 VRECT.n100 VRECT.t22 10.122
R228 VRECT.t0 VRECT.n118 10.122
R229 VRECT.n304 VRECT.t27 7.76999
R230 VRECT.n162 VRECT.t3 7.73189
R231 VRECT.n306 VRECT.t31 7.34934
R232 VRECT.n164 VRECT.t23 7.08174
R233 VRECT.n304 VRECT.t25 6.85919
R234 VRECT.n162 VRECT.t1 6.66989
R235 VRECT.n164 VRECT.t21 6.47874
R236 VRECT.n306 VRECT.t29 6.43854
R237 VRECT.n152 VRECT.n151 6.3005
R238 VRECT.n151 VRECT.n150 6.3005
R239 VRECT.n12 VRECT.n10 6.3005
R240 VRECT.n138 VRECT.n12 6.3005
R241 VRECT.n156 VRECT.n9 6.3005
R242 VRECT.n139 VRECT.n9 6.3005
R243 VRECT.n157 VRECT.n8 6.3005
R244 VRECT.n137 VRECT.n8 6.3005
R245 VRECT.n158 VRECT.n7 6.3005
R246 VRECT.n136 VRECT.n7 6.3005
R247 VRECT.n27 VRECT.n5 6.3005
R248 VRECT.n27 VRECT.n25 6.3005
R249 VRECT.n127 VRECT.n126 6.3005
R250 VRECT.n128 VRECT.n127 6.3005
R251 VRECT.n125 VRECT.n26 6.3005
R252 VRECT.n26 VRECT.n24 6.3005
R253 VRECT.n32 VRECT.n28 6.3005
R254 VRECT.n118 VRECT.n32 6.3005
R255 VRECT.n121 VRECT.n120 6.3005
R256 VRECT.n120 VRECT.n119 6.3005
R257 VRECT.n31 VRECT.n30 6.3005
R258 VRECT.n33 VRECT.n31 6.3005
R259 VRECT.n108 VRECT.n107 6.3005
R260 VRECT.n109 VRECT.n108 6.3005
R261 VRECT.n40 VRECT.n39 6.3005
R262 VRECT.n100 VRECT.n39 6.3005
R263 VRECT.n103 VRECT.n102 6.3005
R264 VRECT.n102 VRECT.n101 6.3005
R265 VRECT.n43 VRECT.n42 6.3005
R266 VRECT.n44 VRECT.n43 6.3005
R267 VRECT.n90 VRECT.n89 6.3005
R268 VRECT.n91 VRECT.n90 6.3005
R269 VRECT.n52 VRECT.n51 6.3005
R270 VRECT.n82 VRECT.n51 6.3005
R271 VRECT.n85 VRECT.n84 6.3005
R272 VRECT.n84 VRECT.n83 6.3005
R273 VRECT.n55 VRECT.n54 6.3005
R274 VRECT.n56 VRECT.n55 6.3005
R275 VRECT.n73 VRECT.n72 6.3005
R276 VRECT.n74 VRECT.n73 6.3005
R277 VRECT.n63 VRECT.n62 6.3005
R278 VRECT.n66 VRECT.n62 6.3005
R279 VRECT.n148 VRECT.n147 6.3005
R280 VRECT.n15 VRECT.n14 6.3005
R281 VRECT.n138 VRECT.n14 6.3005
R282 VRECT.n141 VRECT.n140 6.3005
R283 VRECT.n140 VRECT.n139 6.3005
R284 VRECT.n18 VRECT.n17 6.3005
R285 VRECT.n137 VRECT.n18 6.3005
R286 VRECT.n135 VRECT.n134 6.3005
R287 VRECT.n136 VRECT.n135 6.3005
R288 VRECT.n20 VRECT.n19 6.3005
R289 VRECT.n25 VRECT.n19 6.3005
R290 VRECT.n130 VRECT.n129 6.3005
R291 VRECT.n129 VRECT.n128 6.3005
R292 VRECT.n23 VRECT.n22 6.3005
R293 VRECT.n24 VRECT.n23 6.3005
R294 VRECT.n117 VRECT.n116 6.3005
R295 VRECT.n118 VRECT.n117 6.3005
R296 VRECT.n35 VRECT.n34 6.3005
R297 VRECT.n119 VRECT.n34 6.3005
R298 VRECT.n112 VRECT.n111 6.3005
R299 VRECT.n111 VRECT.n33 6.3005
R300 VRECT.n110 VRECT.n37 6.3005
R301 VRECT.n110 VRECT.n109 6.3005
R302 VRECT.n47 VRECT.n38 6.3005
R303 VRECT.n100 VRECT.n38 6.3005
R304 VRECT.n99 VRECT.n98 6.3005
R305 VRECT.n101 VRECT.n99 6.3005
R306 VRECT.n46 VRECT.n45 6.3005
R307 VRECT.n45 VRECT.n44 6.3005
R308 VRECT.n93 VRECT.n92 6.3005
R309 VRECT.n92 VRECT.n91 6.3005
R310 VRECT.n50 VRECT.n49 6.3005
R311 VRECT.n82 VRECT.n50 6.3005
R312 VRECT.n81 VRECT.n80 6.3005
R313 VRECT.n83 VRECT.n81 6.3005
R314 VRECT.n58 VRECT.n57 6.3005
R315 VRECT.n57 VRECT.n56 6.3005
R316 VRECT.n76 VRECT.n75 6.3005
R317 VRECT.n75 VRECT.n74 6.3005
R318 VRECT.n61 VRECT.n60 6.3005
R319 VRECT.n218 VRECT.n217 6.3005
R320 VRECT.n222 VRECT.n218 6.3005
R321 VRECT.n233 VRECT.n232 6.3005
R322 VRECT.n232 VRECT.n231 6.3005
R323 VRECT.n215 VRECT.n214 6.3005
R324 VRECT.n214 VRECT.n213 6.3005
R325 VRECT.n238 VRECT.n237 6.3005
R326 VRECT.n239 VRECT.n238 6.3005
R327 VRECT.n205 VRECT.n204 6.3005
R328 VRECT.n206 VRECT.n205 6.3005
R329 VRECT.n252 VRECT.n251 6.3005
R330 VRECT.n251 VRECT.n250 6.3005
R331 VRECT.n202 VRECT.n201 6.3005
R332 VRECT.n249 VRECT.n201 6.3005
R333 VRECT.n257 VRECT.n256 6.3005
R334 VRECT.n258 VRECT.n257 6.3005
R335 VRECT.n190 VRECT.n189 6.3005
R336 VRECT.n192 VRECT.n190 6.3005
R337 VRECT.n273 VRECT.n272 6.3005
R338 VRECT.n272 VRECT.n271 6.3005
R339 VRECT.n191 VRECT.n187 6.3005
R340 VRECT.n270 VRECT.n191 6.3005
R341 VRECT.n277 VRECT.n186 6.3005
R342 VRECT.n269 VRECT.n186 6.3005
R343 VRECT.n279 VRECT.n278 6.3005
R344 VRECT.n279 VRECT.n185 6.3005
R345 VRECT.n280 VRECT.n168 6.3005
R346 VRECT.n281 VRECT.n280 6.3005
R347 VRECT.n300 VRECT.n170 6.3005
R348 VRECT.n282 VRECT.n170 6.3005
R349 VRECT.n299 VRECT.n171 6.3005
R350 VRECT.n178 VRECT.n171 6.3005
R351 VRECT.n298 VRECT.n172 6.3005
R352 VRECT.n291 VRECT.n172 6.3005
R353 VRECT.n176 VRECT.n173 6.3005
R354 VRECT.n292 VRECT.n176 6.3005
R355 VRECT.n181 VRECT.n177 6.3005
R356 VRECT.n290 VRECT.n289 6.3005
R357 VRECT.n291 VRECT.n290 6.3005
R358 VRECT.n180 VRECT.n179 6.3005
R359 VRECT.n179 VRECT.n178 6.3005
R360 VRECT.n284 VRECT.n283 6.3005
R361 VRECT.n283 VRECT.n282 6.3005
R362 VRECT.n184 VRECT.n183 6.3005
R363 VRECT.n281 VRECT.n184 6.3005
R364 VRECT.n197 VRECT.n195 6.3005
R365 VRECT.n195 VRECT.n185 6.3005
R366 VRECT.n268 VRECT.n267 6.3005
R367 VRECT.n269 VRECT.n268 6.3005
R368 VRECT.n196 VRECT.n194 6.3005
R369 VRECT.n270 VRECT.n194 6.3005
R370 VRECT.n262 VRECT.n193 6.3005
R371 VRECT.n271 VRECT.n193 6.3005
R372 VRECT.n261 VRECT.n260 6.3005
R373 VRECT.n260 VRECT.n192 6.3005
R374 VRECT.n259 VRECT.n199 6.3005
R375 VRECT.n259 VRECT.n258 6.3005
R376 VRECT.n209 VRECT.n200 6.3005
R377 VRECT.n249 VRECT.n200 6.3005
R378 VRECT.n248 VRECT.n247 6.3005
R379 VRECT.n250 VRECT.n248 6.3005
R380 VRECT.n208 VRECT.n207 6.3005
R381 VRECT.n207 VRECT.n206 6.3005
R382 VRECT.n241 VRECT.n240 6.3005
R383 VRECT.n240 VRECT.n239 6.3005
R384 VRECT.n212 VRECT.n211 6.3005
R385 VRECT.n213 VRECT.n212 6.3005
R386 VRECT.n230 VRECT.n229 6.3005
R387 VRECT.n231 VRECT.n230 6.3005
R388 VRECT.n220 VRECT.n219 6.3005
R389 VRECT.n2 VRECT.n1 6.0729
R390 VRECT.n296 VRECT.n295 5.95287
R391 VRECT.n225 VRECT.n216 5.95287
R392 VRECT.n153 VRECT.n11 5.86584
R393 VRECT.n70 VRECT.n69 5.86584
R394 VRECT.n146 VRECT.n145 5.1566
R395 VRECT.n65 VRECT.n59 5.1566
R396 VRECT.n287 VRECT.n175 5.1458
R397 VRECT.n227 VRECT.n226 5.1458
R398 VRECT.n305 VRECT.n304 4.9739
R399 VRECT.n258 VRECT.t30 4.86941
R400 VRECT.n270 VRECT.t24 4.86941
R401 VRECT.n163 VRECT.n162 4.802
R402 VRECT.n307 VRECT.n306 4.5185
R403 VRECT.n77 VRECT.n76 4.5005
R404 VRECT.n78 VRECT.n58 4.5005
R405 VRECT.n80 VRECT.n79 4.5005
R406 VRECT.n49 VRECT.n48 4.5005
R407 VRECT.n94 VRECT.n93 4.5005
R408 VRECT.n95 VRECT.n46 4.5005
R409 VRECT.n98 VRECT.n97 4.5005
R410 VRECT.n96 VRECT.n47 4.5005
R411 VRECT.n37 VRECT.n36 4.5005
R412 VRECT.n113 VRECT.n112 4.5005
R413 VRECT.n114 VRECT.n35 4.5005
R414 VRECT.n116 VRECT.n115 4.5005
R415 VRECT.n22 VRECT.n21 4.5005
R416 VRECT.n131 VRECT.n130 4.5005
R417 VRECT.n132 VRECT.n20 4.5005
R418 VRECT.n134 VRECT.n133 4.5005
R419 VRECT.n17 VRECT.n16 4.5005
R420 VRECT.n142 VRECT.n141 4.5005
R421 VRECT.n143 VRECT.n15 4.5005
R422 VRECT.n147 VRECT.n146 4.5005
R423 VRECT.n60 VRECT.n59 4.5005
R424 VRECT.n72 VRECT.n71 4.5005
R425 VRECT.n54 VRECT.n53 4.5005
R426 VRECT.n86 VRECT.n85 4.5005
R427 VRECT.n87 VRECT.n52 4.5005
R428 VRECT.n89 VRECT.n88 4.5005
R429 VRECT.n42 VRECT.n41 4.5005
R430 VRECT.n104 VRECT.n103 4.5005
R431 VRECT.n105 VRECT.n40 4.5005
R432 VRECT.n107 VRECT.n106 4.5005
R433 VRECT.n30 VRECT.n29 4.5005
R434 VRECT.n122 VRECT.n121 4.5005
R435 VRECT.n123 VRECT.n28 4.5005
R436 VRECT.n125 VRECT.n124 4.5005
R437 VRECT.n126 VRECT.n4 4.5005
R438 VRECT.n160 VRECT.n5 4.5005
R439 VRECT.n159 VRECT.n158 4.5005
R440 VRECT.n157 VRECT.n6 4.5005
R441 VRECT.n156 VRECT.n155 4.5005
R442 VRECT.n154 VRECT.n10 4.5005
R443 VRECT.n153 VRECT.n152 4.5005
R444 VRECT.n70 VRECT.n63 4.5005
R445 VRECT.n229 VRECT.n228 4.5005
R446 VRECT.n211 VRECT.n210 4.5005
R447 VRECT.n242 VRECT.n241 4.5005
R448 VRECT.n243 VRECT.n208 4.5005
R449 VRECT.n247 VRECT.n246 4.5005
R450 VRECT.n245 VRECT.n209 4.5005
R451 VRECT.n244 VRECT.n199 4.5005
R452 VRECT.n261 VRECT.n198 4.5005
R453 VRECT.n263 VRECT.n262 4.5005
R454 VRECT.n264 VRECT.n196 4.5005
R455 VRECT.n267 VRECT.n266 4.5005
R456 VRECT.n265 VRECT.n197 4.5005
R457 VRECT.n183 VRECT.n182 4.5005
R458 VRECT.n285 VRECT.n284 4.5005
R459 VRECT.n286 VRECT.n180 4.5005
R460 VRECT.n289 VRECT.n288 4.5005
R461 VRECT.n287 VRECT.n181 4.5005
R462 VRECT.n227 VRECT.n220 4.5005
R463 VRECT.n217 VRECT.n216 4.5005
R464 VRECT.n234 VRECT.n233 4.5005
R465 VRECT.n235 VRECT.n215 4.5005
R466 VRECT.n237 VRECT.n236 4.5005
R467 VRECT.n204 VRECT.n203 4.5005
R468 VRECT.n253 VRECT.n252 4.5005
R469 VRECT.n254 VRECT.n202 4.5005
R470 VRECT.n256 VRECT.n255 4.5005
R471 VRECT.n189 VRECT.n188 4.5005
R472 VRECT.n274 VRECT.n273 4.5005
R473 VRECT.n275 VRECT.n187 4.5005
R474 VRECT.n277 VRECT.n276 4.5005
R475 VRECT.n278 VRECT.n167 4.5005
R476 VRECT.n302 VRECT.n168 4.5005
R477 VRECT.n301 VRECT.n300 4.5005
R478 VRECT.n299 VRECT.n169 4.5005
R479 VRECT.n298 VRECT.n297 4.5005
R480 VRECT.n296 VRECT.n173 4.5005
R481 VRECT.n303 VRECT.n302 4.5005
R482 VRECT.n165 VRECT.n164 4.5005
R483 VRECT.n161 VRECT.n160 4.5005
R484 VRECT.n293 VRECT.n177 3.43317
R485 VRECT.n223 VRECT.n219 3.43317
R486 VRECT.n149 VRECT.n148 3.15702
R487 VRECT.n67 VRECT.n61 3.15702
R488 VRECT.n67 VRECT.n66 2.98151
R489 VRECT.n150 VRECT.n149 2.98151
R490 VRECT.n223 VRECT.n222 2.70163
R491 VRECT.n293 VRECT.n292 2.70163
R492 VRECT VRECT.n308 1.61143
R493 VRECT.n308 VRECT.n166 1.52532
R494 VRECT.n174 VRECT.t6 0.858932
R495 VRECT.n221 VRECT.t9 0.858932
R496 VRECT.n144 VRECT.t12 0.836559
R497 VRECT.n64 VRECT.t15 0.836559
R498 VRECT.n295 VRECT.n175 0.717565
R499 VRECT.n226 VRECT.n225 0.717565
R500 VRECT.n1 VRECT.t19 0.67775
R501 VRECT.n1 VRECT.t17 0.67775
R502 VRECT.n145 VRECT.n11 0.619739
R503 VRECT.n69 VRECT.n65 0.619739
R504 VRECT.n145 VRECT.n144 0.299832
R505 VRECT.n65 VRECT.n64 0.299832
R506 VRECT.n13 VRECT.n11 0.286864
R507 VRECT.n69 VRECT.n68 0.286864
R508 VRECT.n175 VRECT.n174 0.282271
R509 VRECT.n226 VRECT.n221 0.282271
R510 VRECT.n295 VRECT.n294 0.263
R511 VRECT.n225 VRECT.n224 0.263
R512 VRECT.n307 VRECT.n305 0.242375
R513 VRECT.n165 VRECT.n163 0.242375
R514 VRECT.n3 VRECT 0.1895
R515 VRECT.n163 VRECT.n161 0.187004
R516 VRECT.n76 VRECT.n60 0.1445
R517 VRECT.n76 VRECT.n58 0.1445
R518 VRECT.n80 VRECT.n58 0.1445
R519 VRECT.n80 VRECT.n49 0.1445
R520 VRECT.n93 VRECT.n49 0.1445
R521 VRECT.n93 VRECT.n46 0.1445
R522 VRECT.n98 VRECT.n46 0.1445
R523 VRECT.n98 VRECT.n47 0.1445
R524 VRECT.n47 VRECT.n37 0.1445
R525 VRECT.n112 VRECT.n37 0.1445
R526 VRECT.n112 VRECT.n35 0.1445
R527 VRECT.n116 VRECT.n35 0.1445
R528 VRECT.n116 VRECT.n22 0.1445
R529 VRECT.n130 VRECT.n22 0.1445
R530 VRECT.n130 VRECT.n20 0.1445
R531 VRECT.n134 VRECT.n20 0.1445
R532 VRECT.n134 VRECT.n17 0.1445
R533 VRECT.n141 VRECT.n17 0.1445
R534 VRECT.n141 VRECT.n15 0.1445
R535 VRECT.n147 VRECT.n15 0.1445
R536 VRECT.n72 VRECT.n63 0.1445
R537 VRECT.n72 VRECT.n54 0.1445
R538 VRECT.n85 VRECT.n54 0.1445
R539 VRECT.n85 VRECT.n52 0.1445
R540 VRECT.n89 VRECT.n52 0.1445
R541 VRECT.n89 VRECT.n42 0.1445
R542 VRECT.n103 VRECT.n42 0.1445
R543 VRECT.n103 VRECT.n40 0.1445
R544 VRECT.n107 VRECT.n40 0.1445
R545 VRECT.n107 VRECT.n30 0.1445
R546 VRECT.n121 VRECT.n30 0.1445
R547 VRECT.n121 VRECT.n28 0.1445
R548 VRECT.n125 VRECT.n28 0.1445
R549 VRECT.n126 VRECT.n125 0.1445
R550 VRECT.n126 VRECT.n5 0.1445
R551 VRECT.n158 VRECT.n5 0.1445
R552 VRECT.n158 VRECT.n157 0.1445
R553 VRECT.n157 VRECT.n156 0.1445
R554 VRECT.n156 VRECT.n10 0.1445
R555 VRECT.n152 VRECT.n10 0.1445
R556 VRECT.n77 VRECT.n59 0.1445
R557 VRECT.n78 VRECT.n77 0.1445
R558 VRECT.n79 VRECT.n78 0.1445
R559 VRECT.n79 VRECT.n48 0.1445
R560 VRECT.n94 VRECT.n48 0.1445
R561 VRECT.n95 VRECT.n94 0.1445
R562 VRECT.n97 VRECT.n95 0.1445
R563 VRECT.n97 VRECT.n96 0.1445
R564 VRECT.n96 VRECT.n36 0.1445
R565 VRECT.n113 VRECT.n36 0.1445
R566 VRECT.n114 VRECT.n113 0.1445
R567 VRECT.n115 VRECT.n114 0.1445
R568 VRECT.n115 VRECT.n21 0.1445
R569 VRECT.n131 VRECT.n21 0.1445
R570 VRECT.n132 VRECT.n131 0.1445
R571 VRECT.n133 VRECT.n132 0.1445
R572 VRECT.n133 VRECT.n16 0.1445
R573 VRECT.n142 VRECT.n16 0.1445
R574 VRECT.n143 VRECT.n142 0.1445
R575 VRECT.n146 VRECT.n143 0.1445
R576 VRECT.n71 VRECT.n70 0.1445
R577 VRECT.n71 VRECT.n53 0.1445
R578 VRECT.n86 VRECT.n53 0.1445
R579 VRECT.n87 VRECT.n86 0.1445
R580 VRECT.n88 VRECT.n87 0.1445
R581 VRECT.n88 VRECT.n41 0.1445
R582 VRECT.n104 VRECT.n41 0.1445
R583 VRECT.n105 VRECT.n104 0.1445
R584 VRECT.n106 VRECT.n105 0.1445
R585 VRECT.n106 VRECT.n29 0.1445
R586 VRECT.n122 VRECT.n29 0.1445
R587 VRECT.n123 VRECT.n122 0.1445
R588 VRECT.n124 VRECT.n123 0.1445
R589 VRECT.n124 VRECT.n4 0.1445
R590 VRECT.n160 VRECT.n4 0.1445
R591 VRECT.n160 VRECT.n159 0.1445
R592 VRECT.n159 VRECT.n6 0.1445
R593 VRECT.n155 VRECT.n6 0.1445
R594 VRECT.n155 VRECT.n154 0.1445
R595 VRECT.n154 VRECT.n153 0.1445
R596 VRECT.n229 VRECT.n220 0.1445
R597 VRECT.n229 VRECT.n211 0.1445
R598 VRECT.n241 VRECT.n211 0.1445
R599 VRECT.n241 VRECT.n208 0.1445
R600 VRECT.n247 VRECT.n208 0.1445
R601 VRECT.n247 VRECT.n209 0.1445
R602 VRECT.n209 VRECT.n199 0.1445
R603 VRECT.n261 VRECT.n199 0.1445
R604 VRECT.n262 VRECT.n261 0.1445
R605 VRECT.n262 VRECT.n196 0.1445
R606 VRECT.n267 VRECT.n196 0.1445
R607 VRECT.n267 VRECT.n197 0.1445
R608 VRECT.n197 VRECT.n183 0.1445
R609 VRECT.n284 VRECT.n183 0.1445
R610 VRECT.n284 VRECT.n180 0.1445
R611 VRECT.n289 VRECT.n180 0.1445
R612 VRECT.n289 VRECT.n181 0.1445
R613 VRECT.n233 VRECT.n217 0.1445
R614 VRECT.n233 VRECT.n215 0.1445
R615 VRECT.n237 VRECT.n215 0.1445
R616 VRECT.n237 VRECT.n204 0.1445
R617 VRECT.n252 VRECT.n204 0.1445
R618 VRECT.n252 VRECT.n202 0.1445
R619 VRECT.n256 VRECT.n202 0.1445
R620 VRECT.n256 VRECT.n189 0.1445
R621 VRECT.n273 VRECT.n189 0.1445
R622 VRECT.n273 VRECT.n187 0.1445
R623 VRECT.n277 VRECT.n187 0.1445
R624 VRECT.n278 VRECT.n277 0.1445
R625 VRECT.n278 VRECT.n168 0.1445
R626 VRECT.n300 VRECT.n168 0.1445
R627 VRECT.n300 VRECT.n299 0.1445
R628 VRECT.n299 VRECT.n298 0.1445
R629 VRECT.n298 VRECT.n173 0.1445
R630 VRECT.n228 VRECT.n227 0.1445
R631 VRECT.n228 VRECT.n210 0.1445
R632 VRECT.n242 VRECT.n210 0.1445
R633 VRECT.n243 VRECT.n242 0.1445
R634 VRECT.n246 VRECT.n243 0.1445
R635 VRECT.n246 VRECT.n245 0.1445
R636 VRECT.n245 VRECT.n244 0.1445
R637 VRECT.n244 VRECT.n198 0.1445
R638 VRECT.n263 VRECT.n198 0.1445
R639 VRECT.n264 VRECT.n263 0.1445
R640 VRECT.n266 VRECT.n264 0.1445
R641 VRECT.n266 VRECT.n265 0.1445
R642 VRECT.n265 VRECT.n182 0.1445
R643 VRECT.n285 VRECT.n182 0.1445
R644 VRECT.n286 VRECT.n285 0.1445
R645 VRECT.n288 VRECT.n286 0.1445
R646 VRECT.n288 VRECT.n287 0.1445
R647 VRECT.n234 VRECT.n216 0.1445
R648 VRECT.n235 VRECT.n234 0.1445
R649 VRECT.n236 VRECT.n235 0.1445
R650 VRECT.n236 VRECT.n203 0.1445
R651 VRECT.n253 VRECT.n203 0.1445
R652 VRECT.n254 VRECT.n253 0.1445
R653 VRECT.n255 VRECT.n254 0.1445
R654 VRECT.n255 VRECT.n188 0.1445
R655 VRECT.n274 VRECT.n188 0.1445
R656 VRECT.n275 VRECT.n274 0.1445
R657 VRECT.n276 VRECT.n275 0.1445
R658 VRECT.n276 VRECT.n167 0.1445
R659 VRECT.n302 VRECT.n167 0.1445
R660 VRECT.n302 VRECT.n301 0.1445
R661 VRECT.n301 VRECT.n169 0.1445
R662 VRECT.n297 VRECT.n169 0.1445
R663 VRECT.n297 VRECT.n296 0.1445
R664 VRECT.n3 VRECT.n2 0.1067
R665 VRECT.n305 VRECT.n303 0.0891134
R666 VRECT.n161 VRECT 0.00567241
R667 VRECT.n303 VRECT 0.00468605
R668 VSS.n805 VSS.n804 6213.14
R669 VSS.n806 VSS.n805 4445.29
R670 VSS.n410 VSS.n408 227.185
R671 VSS.n805 VSS.n613 221.008
R672 VSS.n804 VSS.n770 185.534
R673 VSS.n804 VSS.n803 185.534
R674 VSS.n838 VSS.n807 124.153
R675 VSS.n807 VSS.n48 124.153
R676 VSS.n802 VSS.n773 124.153
R677 VSS.n802 VSS.n772 124.153
R678 VSS.n559 VSS.n558 119.769
R679 VSS.n533 VSS.n513 119.769
R680 VSS.n680 VSS.n676 115.597
R681 VSS.n769 VSS.n616 115.597
R682 VSS.n680 VSS.n678 115.597
R683 VSS.n769 VSS.n617 115.597
R684 VSS.n512 VSS.n475 101.793
R685 VSS.n612 VSS.n50 101.793
R686 VSS.n612 VSS.n51 101.793
R687 VSS.n512 VSS.n476 101.793
R688 VSS.n532 VSS.n471 101.793
R689 VSS.n532 VSS.n473 101.793
R690 VSS.n557 VSS.n441 101.793
R691 VSS.n557 VSS.n440 101.793
R692 VSS.n573 VSS.n560 101.793
R693 VSS.n560 VSS.n438 101.793
R694 VSS.n411 VSS.n84 101.793
R695 VSS.n411 VSS.n85 101.793
R696 VSS.n407 VSS.n90 72.0422
R697 VSS.n407 VSS.n91 72.0422
R698 VSS.n229 VSS.n221 72.0422
R699 VSS.n568 VSS.t12 70.1068
R700 VSS.n87 VSS.t15 70.1068
R701 VSS.n529 VSS.t6 70.1068
R702 VSS.n443 VSS.t9 70.1068
R703 VSS.n609 VSS.t0 70.1068
R704 VSS.n478 VSS.t3 70.1068
R705 VSS.n833 VSS.t24 57.071
R706 VSS.n775 VSS.t27 57.071
R707 VSS.n677 VSS.n614 31.0322
R708 VSS.n770 VSS.n615 31.0322
R709 VSS.n803 VSS.n771 29.7164
R710 VSS.n839 VSS.n806 29.7164
R711 VSS.n154 VSS.n4 24.1848
R712 VSS.n766 VSS.t30 21.9196
R713 VSS.n682 VSS.t33 21.9196
R714 VSS.n588 VSS.n4 20.8642
R715 VSS VSS.n871 18.9641
R716 VSS.n870 VSS 18.8516
R717 VSS.n154 VSS.t47 18.6535
R718 VSS.n410 VSS.n409 17.8584
R719 VSS.n574 VSS.n559 17.8584
R720 VSS.n558 VSS.n439 17.8584
R721 VSS.n534 VSS.n533 17.8584
R722 VSS.n513 VSS.n474 17.8584
R723 VSS.n613 VSS.n49 17.8584
R724 VSS.n688 VSS.n670 17.545
R725 VSS.n696 VSS.n670 17.545
R726 VSS.n696 VSS.n671 17.545
R727 VSS.n704 VSS.n658 17.545
R728 VSS.n712 VSS.n658 17.545
R729 VSS.n712 VSS.n659 17.545
R730 VSS.n720 VSS.n647 17.545
R731 VSS.n728 VSS.n647 17.545
R732 VSS.n736 VSS.n641 17.545
R733 VSS.n736 VSS.n635 17.545
R734 VSS.n744 VSS.n635 17.545
R735 VSS.n753 VSS.n629 17.545
R736 VSS.n753 VSS.n622 17.545
R737 VSS.n761 VSS.n622 17.545
R738 VSS.n794 VSS.n781 17.545
R739 VSS.n794 VSS.n782 17.545
R740 VSS.n863 VSS.n14 17.545
R741 VSS.n863 VSS.n15 17.545
R742 VSS.n857 VSS.n856 17.545
R743 VSS.n856 VSS.n855 17.545
R744 VSS.n855 VSS.n27 17.545
R745 VSS.n849 VSS.n848 17.545
R746 VSS.n848 VSS.n847 17.545
R747 VSS.n841 VSS.n45 17.545
R748 VSS.n841 VSS.n840 17.545
R749 VSS.n408 VSS.n89 17.3884
R750 VSS.t58 VSS.n15 16.1195
R751 VSS.n849 VSS.t52 16.1195
R752 VSS.n93 VSS.t18 15.9002
R753 VSS.n222 VSS.t21 15.9002
R754 VSS.n777 VSS.n773 15.5561
R755 VSS.n795 VSS.n777 15.5561
R756 VSS.n795 VSS.n780 15.5561
R757 VSS.n780 VSS.n12 15.5561
R758 VSS.n864 VSS.n12 15.5561
R759 VSS.n864 VSS.n13 15.5561
R760 VSS.n24 VSS.n13 15.5561
R761 VSS.n25 VSS.n24 15.5561
R762 VSS.n26 VSS.n25 15.5561
R763 VSS.n813 VSS.n26 15.5561
R764 VSS.n813 VSS.n35 15.5561
R765 VSS.n36 VSS.n35 15.5561
R766 VSS.n37 VSS.n36 15.5561
R767 VSS.n810 VSS.n37 15.5561
R768 VSS.n810 VSS.n46 15.5561
R769 VSS.n47 VSS.n46 15.5561
R770 VSS.n48 VSS.n47 15.5561
R771 VSS.n783 VSS.n772 15.5561
R772 VSS.n793 VSS.n783 15.5561
R773 VSS.n793 VSS.n784 15.5561
R774 VSS.n784 VSS.n16 15.5561
R775 VSS.n862 VSS.n16 15.5561
R776 VSS.n862 VSS.n17 15.5561
R777 VSS.n858 VSS.n17 15.5561
R778 VSS.n858 VSS.n23 15.5561
R779 VSS.n854 VSS.n23 15.5561
R780 VSS.n854 VSS.n28 15.5561
R781 VSS.n850 VSS.n28 15.5561
R782 VSS.n850 VSS.n34 15.5561
R783 VSS.n846 VSS.n34 15.5561
R784 VSS.n846 VSS.n38 15.5561
R785 VSS.n842 VSS.n38 15.5561
R786 VSS.n842 VSS.n44 15.5561
R787 VSS.n838 VSS.n44 15.5561
R788 VSS.n487 VSS.n475 15.5561
R789 VSS.n503 VSS.n487 15.5561
R790 VSS.n503 VSS.n488 15.5561
R791 VSS.n499 VSS.n488 15.5561
R792 VSS.n499 VSS.n61 15.5561
R793 VSS.n596 VSS.n61 15.5561
R794 VSS.n596 VSS.n57 15.5561
R795 VSS.n603 VSS.n57 15.5561
R796 VSS.n603 VSS.n50 15.5561
R797 VSS.n480 VSS.n476 15.5561
R798 VSS.n505 VSS.n480 15.5561
R799 VSS.n505 VSS.n484 15.5561
R800 VSS.n496 VSS.n484 15.5561
R801 VSS.n496 VSS.n62 15.5561
R802 VSS.n594 VSS.n62 15.5561
R803 VSS.n594 VSS.n55 15.5561
R804 VSS.n605 VSS.n55 15.5561
R805 VSS.n605 VSS.n51 15.5561
R806 VSS.n445 VSS.n441 15.5561
R807 VSS.n550 VSS.n445 15.5561
R808 VSS.n550 VSS.n448 15.5561
R809 VSS.n461 VSS.n448 15.5561
R810 VSS.n462 VSS.n461 15.5561
R811 VSS.n463 VSS.n462 15.5561
R812 VSS.n524 VSS.n463 15.5561
R813 VSS.n524 VSS.n472 15.5561
R814 VSS.n473 VSS.n472 15.5561
R815 VSS.n451 VSS.n440 15.5561
R816 VSS.n548 VSS.n451 15.5561
R817 VSS.n548 VSS.n452 15.5561
R818 VSS.n544 VSS.n452 15.5561
R819 VSS.n544 VSS.n460 15.5561
R820 VSS.n540 VSS.n460 15.5561
R821 VSS.n540 VSS.n465 15.5561
R822 VSS.n536 VSS.n465 15.5561
R823 VSS.n536 VSS.n471 15.5561
R824 VSS.n418 VSS.n84 15.5561
R825 VSS.n418 VSS.n80 15.5561
R826 VSS.n424 VSS.n80 15.5561
R827 VSS.n424 VSS.n70 15.5561
R828 VSS.n583 VSS.n70 15.5561
R829 VSS.n583 VSS.n71 15.5561
R830 VSS.n436 VSS.n71 15.5561
R831 VSS.n437 VSS.n436 15.5561
R832 VSS.n438 VSS.n437 15.5561
R833 VSS.n416 VSS.n85 15.5561
R834 VSS.n416 VSS.n78 15.5561
R835 VSS.n426 VSS.n78 15.5561
R836 VSS.n426 VSS.n73 15.5561
R837 VSS.n581 VSS.n73 15.5561
R838 VSS.n581 VSS.n74 15.5561
R839 VSS.n577 VSS.n74 15.5561
R840 VSS.n577 VSS.n434 15.5561
R841 VSS.n573 VSS.n434 15.5561
R842 VSS.n226 VSS.n216 15.5561
R843 VSS.n237 VSS.n216 15.5561
R844 VSS.n237 VSS.n212 15.5561
R845 VSS.n243 VSS.n212 15.5561
R846 VSS.n243 VSS.n204 15.5561
R847 VSS.n253 VSS.n204 15.5561
R848 VSS.n253 VSS.n200 15.5561
R849 VSS.n259 VSS.n200 15.5561
R850 VSS.n259 VSS.n192 15.5561
R851 VSS.n269 VSS.n192 15.5561
R852 VSS.n269 VSS.n188 15.5561
R853 VSS.n275 VSS.n188 15.5561
R854 VSS.n275 VSS.n180 15.5561
R855 VSS.n285 VSS.n180 15.5561
R856 VSS.n285 VSS.n176 15.5561
R857 VSS.n291 VSS.n176 15.5561
R858 VSS.n291 VSS.n168 15.5561
R859 VSS.n301 VSS.n168 15.5561
R860 VSS.n301 VSS.n164 15.5561
R861 VSS.n308 VSS.n164 15.5561
R862 VSS.n308 VSS.n157 15.5561
R863 VSS.n319 VSS.n157 15.5561
R864 VSS.n319 VSS.n152 15.5561
R865 VSS.n325 VSS.n152 15.5561
R866 VSS.n325 VSS.n144 15.5561
R867 VSS.n335 VSS.n144 15.5561
R868 VSS.n335 VSS.n140 15.5561
R869 VSS.n341 VSS.n140 15.5561
R870 VSS.n341 VSS.n132 15.5561
R871 VSS.n351 VSS.n132 15.5561
R872 VSS.n351 VSS.n128 15.5561
R873 VSS.n357 VSS.n128 15.5561
R874 VSS.n357 VSS.n120 15.5561
R875 VSS.n367 VSS.n120 15.5561
R876 VSS.n367 VSS.n116 15.5561
R877 VSS.n373 VSS.n116 15.5561
R878 VSS.n373 VSS.n108 15.5561
R879 VSS.n383 VSS.n108 15.5561
R880 VSS.n383 VSS.n104 15.5561
R881 VSS.n390 VSS.n104 15.5561
R882 VSS.n390 VSS.n96 15.5561
R883 VSS.n401 VSS.n96 15.5561
R884 VSS.n401 VSS.n91 15.5561
R885 VSS.n229 VSS.n218 15.5561
R886 VSS.n235 VSS.n218 15.5561
R887 VSS.n235 VSS.n210 15.5561
R888 VSS.n245 VSS.n210 15.5561
R889 VSS.n245 VSS.n206 15.5561
R890 VSS.n251 VSS.n206 15.5561
R891 VSS.n251 VSS.n198 15.5561
R892 VSS.n261 VSS.n198 15.5561
R893 VSS.n261 VSS.n194 15.5561
R894 VSS.n267 VSS.n194 15.5561
R895 VSS.n267 VSS.n186 15.5561
R896 VSS.n277 VSS.n186 15.5561
R897 VSS.n277 VSS.n182 15.5561
R898 VSS.n283 VSS.n182 15.5561
R899 VSS.n283 VSS.n174 15.5561
R900 VSS.n293 VSS.n174 15.5561
R901 VSS.n293 VSS.n170 15.5561
R902 VSS.n299 VSS.n170 15.5561
R903 VSS.n299 VSS.n162 15.5561
R904 VSS.n311 VSS.n162 15.5561
R905 VSS.n311 VSS.n158 15.5561
R906 VSS.n317 VSS.n158 15.5561
R907 VSS.n317 VSS.n150 15.5561
R908 VSS.n327 VSS.n150 15.5561
R909 VSS.n327 VSS.n146 15.5561
R910 VSS.n333 VSS.n146 15.5561
R911 VSS.n333 VSS.n138 15.5561
R912 VSS.n343 VSS.n138 15.5561
R913 VSS.n343 VSS.n134 15.5561
R914 VSS.n349 VSS.n134 15.5561
R915 VSS.n349 VSS.n126 15.5561
R916 VSS.n359 VSS.n126 15.5561
R917 VSS.n359 VSS.n122 15.5561
R918 VSS.n365 VSS.n122 15.5561
R919 VSS.n365 VSS.n114 15.5561
R920 VSS.n375 VSS.n114 15.5561
R921 VSS.n375 VSS.n110 15.5561
R922 VSS.n381 VSS.n110 15.5561
R923 VSS.n381 VSS.n102 15.5561
R924 VSS.n392 VSS.n102 15.5561
R925 VSS.n392 VSS.n98 15.5561
R926 VSS.n399 VSS.n98 15.5561
R927 VSS.n399 VSS.n90 15.5561
R928 VSS.n689 VSS.n676 15.5561
R929 VSS.n689 VSS.n672 15.5561
R930 VSS.n695 VSS.n672 15.5561
R931 VSS.n695 VSS.n664 15.5561
R932 VSS.n705 VSS.n664 15.5561
R933 VSS.n705 VSS.n660 15.5561
R934 VSS.n711 VSS.n660 15.5561
R935 VSS.n711 VSS.n652 15.5561
R936 VSS.n721 VSS.n652 15.5561
R937 VSS.n721 VSS.n648 15.5561
R938 VSS.n727 VSS.n648 15.5561
R939 VSS.n727 VSS.n640 15.5561
R940 VSS.n737 VSS.n640 15.5561
R941 VSS.n737 VSS.n636 15.5561
R942 VSS.n743 VSS.n636 15.5561
R943 VSS.n743 VSS.n628 15.5561
R944 VSS.n754 VSS.n628 15.5561
R945 VSS.n754 VSS.n623 15.5561
R946 VSS.n760 VSS.n623 15.5561
R947 VSS.n760 VSS.n616 15.5561
R948 VSS.n687 VSS.n678 15.5561
R949 VSS.n687 VSS.n669 15.5561
R950 VSS.n697 VSS.n669 15.5561
R951 VSS.n697 VSS.n665 15.5561
R952 VSS.n703 VSS.n665 15.5561
R953 VSS.n703 VSS.n657 15.5561
R954 VSS.n713 VSS.n657 15.5561
R955 VSS.n713 VSS.n653 15.5561
R956 VSS.n719 VSS.n653 15.5561
R957 VSS.n719 VSS.n646 15.5561
R958 VSS.n729 VSS.n646 15.5561
R959 VSS.n729 VSS.n642 15.5561
R960 VSS.n735 VSS.n642 15.5561
R961 VSS.n735 VSS.n634 15.5561
R962 VSS.n745 VSS.n634 15.5561
R963 VSS.n745 VSS.n630 15.5561
R964 VSS.n752 VSS.n630 15.5561
R965 VSS.n752 VSS.n621 15.5561
R966 VSS.n762 VSS.n621 15.5561
R967 VSS.n762 VSS.n617 15.5561
R968 VSS.n720 VSS.t50 14.8036
R969 VSS.n728 VSS.t38 14.8036
R970 VSS.n227 VSS.n221 13.6396
R971 VSS.n782 VSS.t54 13.2685
R972 VSS.n45 VSS.t56 13.2685
R973 VSS.n677 VSS.t34 11.7334
R974 VSS.t31 VSS.n615 11.7334
R975 VSS.n228 VSS.n217 10.7421
R976 VSS.n236 VSS.n217 10.7421
R977 VSS.n236 VSS.n211 10.7421
R978 VSS.n244 VSS.n211 10.7421
R979 VSS.n244 VSS.n205 10.7421
R980 VSS.n252 VSS.n205 10.7421
R981 VSS.n260 VSS.n199 10.7421
R982 VSS.n260 VSS.n193 10.7421
R983 VSS.n268 VSS.n193 10.7421
R984 VSS.n268 VSS.n187 10.7421
R985 VSS.n276 VSS.n187 10.7421
R986 VSS.n276 VSS.n181 10.7421
R987 VSS.n284 VSS.n181 10.7421
R988 VSS.n284 VSS.n175 10.7421
R989 VSS.n292 VSS.n175 10.7421
R990 VSS.n292 VSS.n169 10.7421
R991 VSS.n300 VSS.n169 10.7421
R992 VSS.n300 VSS.n163 10.7421
R993 VSS.n310 VSS.n163 10.7421
R994 VSS.n310 VSS.n309 10.7421
R995 VSS.n318 VSS.n151 10.7421
R996 VSS.n326 VSS.n151 10.7421
R997 VSS.n326 VSS.n145 10.7421
R998 VSS.n334 VSS.n145 10.7421
R999 VSS.n334 VSS.n139 10.7421
R1000 VSS.n342 VSS.n139 10.7421
R1001 VSS.n342 VSS.n133 10.7421
R1002 VSS.n350 VSS.n133 10.7421
R1003 VSS.n350 VSS.n127 10.7421
R1004 VSS.n358 VSS.n127 10.7421
R1005 VSS.n358 VSS.n121 10.7421
R1006 VSS.n366 VSS.n121 10.7421
R1007 VSS.n366 VSS.n115 10.7421
R1008 VSS.n374 VSS.n115 10.7421
R1009 VSS.n382 VSS.n109 10.7421
R1010 VSS.n382 VSS.n103 10.7421
R1011 VSS.n391 VSS.n103 10.7421
R1012 VSS.n391 VSS.n97 10.7421
R1013 VSS.n400 VSS.n97 10.7421
R1014 VSS.n400 VSS.n89 10.7421
R1015 VSS.n417 VSS.n79 10.7421
R1016 VSS.n425 VSS.n79 10.7421
R1017 VSS.n582 VSS.n72 10.7421
R1018 VSS.n576 VSS.n435 10.7421
R1019 VSS.n576 VSS.n575 10.7421
R1020 VSS.n549 VSS.n449 10.7421
R1021 VSS.n549 VSS.n450 10.7421
R1022 VSS.n543 VSS.n542 10.7421
R1023 VSS.n541 VSS.n464 10.7421
R1024 VSS.n535 VSS.n464 10.7421
R1025 VSS.n504 VSS.n485 10.7421
R1026 VSS.n504 VSS.n486 10.7421
R1027 VSS.n498 VSS.n497 10.7421
R1028 VSS.n595 VSS.n56 10.7421
R1029 VSS.n604 VSS.n56 10.7421
R1030 VSS.n805 VSS.n614 10.0886
R1031 VSS.n704 VSS.t40 9.32099
R1032 VSS.n744 VSS.t48 9.32099
R1033 VSS.n0 VSS.t39 9.30368
R1034 VSS.n781 VSS.t28 9.10168
R1035 VSS.n840 VSS.t25 9.10168
R1036 VSS.n1 VSS.t49 8.88303
R1037 VSS.n425 VSS.t43 8.4595
R1038 VSS.n435 VSS.t42 8.4595
R1039 VSS.t37 VSS.n450 8.4595
R1040 VSS.t36 VSS.n541 8.4595
R1041 VSS.t45 VSS.n486 8.4595
R1042 VSS.n595 VSS.t44 8.4595
R1043 VSS.t28 VSS.n771 8.44377
R1044 VSS.t25 VSS.n839 8.44377
R1045 VSS.n5 VSS.t53 8.393
R1046 VSS.n0 VSS.t41 8.24168
R1047 VSS.n671 VSS.t40 8.22446
R1048 VSS.t48 VSS.n629 8.22446
R1049 VSS.n6 VSS.t57 8.15955
R1050 VSS.n5 VSS.t55 7.8566
R1051 VSS.n1 VSS.t51 7.82103
R1052 VSS.n6 VSS.t59 7.24875
R1053 VSS.t22 VSS.n199 5.90837
R1054 VSS.n374 VSS.t19 5.90837
R1055 VSS.n688 VSS.t34 5.8121
R1056 VSS.n761 VSS.t31 5.8121
R1057 VSS.n836 VSS.n835 5.75623
R1058 VSS.n801 VSS.n774 5.75623
R1059 VSS.n768 VSS.n618 5.66921
R1060 VSS.n681 VSS.n674 5.66921
R1061 VSS.n571 VSS.n570 5.53163
R1062 VSS.n413 VSS.n412 5.53163
R1063 VSS.n531 VSS.n514 5.53163
R1064 VSS.n556 VSS.n442 5.53163
R1065 VSS.n611 VSS.n52 5.53163
R1066 VSS.n511 VSS.n477 5.53163
R1067 VSS.n409 VSS.t16 5.50556
R1068 VSS.t13 VSS.n574 5.50556
R1069 VSS.t10 VSS.n439 5.50556
R1070 VSS.t7 VSS.n534 5.50556
R1071 VSS.t4 VSS.n474 5.50556
R1072 VSS.t1 VSS.n49 5.50556
R1073 VSS.n587 VSS.n586 5.5013
R1074 VSS.n309 VSS.t46 5.37129
R1075 VSS.n318 VSS.t46 5.37129
R1076 VSS.n417 VSS.t16 5.23702
R1077 VSS.n575 VSS.t13 5.23702
R1078 VSS.n449 VSS.t10 5.23702
R1079 VSS.n535 VSS.t7 5.23702
R1080 VSS.n485 VSS.t4 5.23702
R1081 VSS.n604 VSS.t1 5.23702
R1082 VSS.n406 VSS.n92 5.23283
R1083 VSS.n231 VSS.n220 5.23283
R1084 VSS.n397 VSS.n90 5.2005
R1085 VSS.n90 VSS.n89 5.2005
R1086 VSS.n399 VSS.n398 5.2005
R1087 VSS.n400 VSS.n399 5.2005
R1088 VSS.n99 VSS.n98 5.2005
R1089 VSS.n98 VSS.n97 5.2005
R1090 VSS.n393 VSS.n392 5.2005
R1091 VSS.n392 VSS.n391 5.2005
R1092 VSS.n102 VSS.n101 5.2005
R1093 VSS.n103 VSS.n102 5.2005
R1094 VSS.n381 VSS.n380 5.2005
R1095 VSS.n382 VSS.n381 5.2005
R1096 VSS.n111 VSS.n110 5.2005
R1097 VSS.n110 VSS.n109 5.2005
R1098 VSS.n376 VSS.n375 5.2005
R1099 VSS.n375 VSS.n374 5.2005
R1100 VSS.n114 VSS.n113 5.2005
R1101 VSS.n115 VSS.n114 5.2005
R1102 VSS.n365 VSS.n364 5.2005
R1103 VSS.n366 VSS.n365 5.2005
R1104 VSS.n123 VSS.n122 5.2005
R1105 VSS.n122 VSS.n121 5.2005
R1106 VSS.n360 VSS.n359 5.2005
R1107 VSS.n359 VSS.n358 5.2005
R1108 VSS.n126 VSS.n125 5.2005
R1109 VSS.n127 VSS.n126 5.2005
R1110 VSS.n349 VSS.n348 5.2005
R1111 VSS.n350 VSS.n349 5.2005
R1112 VSS.n135 VSS.n134 5.2005
R1113 VSS.n134 VSS.n133 5.2005
R1114 VSS.n344 VSS.n343 5.2005
R1115 VSS.n343 VSS.n342 5.2005
R1116 VSS.n138 VSS.n137 5.2005
R1117 VSS.n139 VSS.n138 5.2005
R1118 VSS.n333 VSS.n332 5.2005
R1119 VSS.n334 VSS.n333 5.2005
R1120 VSS.n147 VSS.n146 5.2005
R1121 VSS.n146 VSS.n145 5.2005
R1122 VSS.n328 VSS.n327 5.2005
R1123 VSS.n327 VSS.n326 5.2005
R1124 VSS.n150 VSS.n149 5.2005
R1125 VSS.n151 VSS.n150 5.2005
R1126 VSS.n317 VSS.n316 5.2005
R1127 VSS.n318 VSS.n317 5.2005
R1128 VSS.n159 VSS.n158 5.2005
R1129 VSS.n309 VSS.n158 5.2005
R1130 VSS.n312 VSS.n311 5.2005
R1131 VSS.n311 VSS.n310 5.2005
R1132 VSS.n162 VSS.n161 5.2005
R1133 VSS.n163 VSS.n162 5.2005
R1134 VSS.n299 VSS.n298 5.2005
R1135 VSS.n300 VSS.n299 5.2005
R1136 VSS.n171 VSS.n170 5.2005
R1137 VSS.n170 VSS.n169 5.2005
R1138 VSS.n294 VSS.n293 5.2005
R1139 VSS.n293 VSS.n292 5.2005
R1140 VSS.n174 VSS.n173 5.2005
R1141 VSS.n175 VSS.n174 5.2005
R1142 VSS.n283 VSS.n282 5.2005
R1143 VSS.n284 VSS.n283 5.2005
R1144 VSS.n183 VSS.n182 5.2005
R1145 VSS.n182 VSS.n181 5.2005
R1146 VSS.n278 VSS.n277 5.2005
R1147 VSS.n277 VSS.n276 5.2005
R1148 VSS.n186 VSS.n185 5.2005
R1149 VSS.n187 VSS.n186 5.2005
R1150 VSS.n267 VSS.n266 5.2005
R1151 VSS.n268 VSS.n267 5.2005
R1152 VSS.n195 VSS.n194 5.2005
R1153 VSS.n194 VSS.n193 5.2005
R1154 VSS.n262 VSS.n261 5.2005
R1155 VSS.n261 VSS.n260 5.2005
R1156 VSS.n198 VSS.n197 5.2005
R1157 VSS.n199 VSS.n198 5.2005
R1158 VSS.n251 VSS.n250 5.2005
R1159 VSS.n252 VSS.n251 5.2005
R1160 VSS.n207 VSS.n206 5.2005
R1161 VSS.n206 VSS.n205 5.2005
R1162 VSS.n246 VSS.n245 5.2005
R1163 VSS.n245 VSS.n244 5.2005
R1164 VSS.n210 VSS.n209 5.2005
R1165 VSS.n211 VSS.n210 5.2005
R1166 VSS.n235 VSS.n234 5.2005
R1167 VSS.n236 VSS.n235 5.2005
R1168 VSS.n219 VSS.n218 5.2005
R1169 VSS.n218 VSS.n217 5.2005
R1170 VSS.n230 VSS.n229 5.2005
R1171 VSS.n229 VSS.n228 5.2005
R1172 VSS.n403 VSS.n91 5.2005
R1173 VSS.n91 VSS.n89 5.2005
R1174 VSS.n402 VSS.n401 5.2005
R1175 VSS.n401 VSS.n400 5.2005
R1176 VSS.n96 VSS.n95 5.2005
R1177 VSS.n97 VSS.n96 5.2005
R1178 VSS.n390 VSS.n389 5.2005
R1179 VSS.n391 VSS.n390 5.2005
R1180 VSS.n105 VSS.n104 5.2005
R1181 VSS.n104 VSS.n103 5.2005
R1182 VSS.n384 VSS.n383 5.2005
R1183 VSS.n383 VSS.n382 5.2005
R1184 VSS.n108 VSS.n107 5.2005
R1185 VSS.n109 VSS.n108 5.2005
R1186 VSS.n373 VSS.n372 5.2005
R1187 VSS.n374 VSS.n373 5.2005
R1188 VSS.n117 VSS.n116 5.2005
R1189 VSS.n116 VSS.n115 5.2005
R1190 VSS.n368 VSS.n367 5.2005
R1191 VSS.n367 VSS.n366 5.2005
R1192 VSS.n120 VSS.n119 5.2005
R1193 VSS.n121 VSS.n120 5.2005
R1194 VSS.n357 VSS.n356 5.2005
R1195 VSS.n358 VSS.n357 5.2005
R1196 VSS.n129 VSS.n128 5.2005
R1197 VSS.n128 VSS.n127 5.2005
R1198 VSS.n352 VSS.n351 5.2005
R1199 VSS.n351 VSS.n350 5.2005
R1200 VSS.n132 VSS.n131 5.2005
R1201 VSS.n133 VSS.n132 5.2005
R1202 VSS.n341 VSS.n340 5.2005
R1203 VSS.n342 VSS.n341 5.2005
R1204 VSS.n141 VSS.n140 5.2005
R1205 VSS.n140 VSS.n139 5.2005
R1206 VSS.n336 VSS.n335 5.2005
R1207 VSS.n335 VSS.n334 5.2005
R1208 VSS.n144 VSS.n143 5.2005
R1209 VSS.n145 VSS.n144 5.2005
R1210 VSS.n325 VSS.n324 5.2005
R1211 VSS.n326 VSS.n325 5.2005
R1212 VSS.n153 VSS.n152 5.2005
R1213 VSS.n152 VSS.n151 5.2005
R1214 VSS.n320 VSS.n319 5.2005
R1215 VSS.n319 VSS.n318 5.2005
R1216 VSS.n157 VSS.n156 5.2005
R1217 VSS.n309 VSS.n157 5.2005
R1218 VSS.n308 VSS.n307 5.2005
R1219 VSS.n310 VSS.n308 5.2005
R1220 VSS.n165 VSS.n164 5.2005
R1221 VSS.n164 VSS.n163 5.2005
R1222 VSS.n302 VSS.n301 5.2005
R1223 VSS.n301 VSS.n300 5.2005
R1224 VSS.n168 VSS.n167 5.2005
R1225 VSS.n169 VSS.n168 5.2005
R1226 VSS.n291 VSS.n290 5.2005
R1227 VSS.n292 VSS.n291 5.2005
R1228 VSS.n177 VSS.n176 5.2005
R1229 VSS.n176 VSS.n175 5.2005
R1230 VSS.n286 VSS.n285 5.2005
R1231 VSS.n285 VSS.n284 5.2005
R1232 VSS.n180 VSS.n179 5.2005
R1233 VSS.n181 VSS.n180 5.2005
R1234 VSS.n275 VSS.n274 5.2005
R1235 VSS.n276 VSS.n275 5.2005
R1236 VSS.n189 VSS.n188 5.2005
R1237 VSS.n188 VSS.n187 5.2005
R1238 VSS.n270 VSS.n269 5.2005
R1239 VSS.n269 VSS.n268 5.2005
R1240 VSS.n192 VSS.n191 5.2005
R1241 VSS.n193 VSS.n192 5.2005
R1242 VSS.n259 VSS.n258 5.2005
R1243 VSS.n260 VSS.n259 5.2005
R1244 VSS.n201 VSS.n200 5.2005
R1245 VSS.n200 VSS.n199 5.2005
R1246 VSS.n254 VSS.n253 5.2005
R1247 VSS.n253 VSS.n252 5.2005
R1248 VSS.n204 VSS.n203 5.2005
R1249 VSS.n205 VSS.n204 5.2005
R1250 VSS.n243 VSS.n242 5.2005
R1251 VSS.n244 VSS.n243 5.2005
R1252 VSS.n213 VSS.n212 5.2005
R1253 VSS.n212 VSS.n211 5.2005
R1254 VSS.n238 VSS.n237 5.2005
R1255 VSS.n237 VSS.n236 5.2005
R1256 VSS.n216 VSS.n215 5.2005
R1257 VSS.n217 VSS.n216 5.2005
R1258 VSS.n226 VSS.n225 5.2005
R1259 VSS.n573 VSS.n572 5.2005
R1260 VSS.n574 VSS.n573 5.2005
R1261 VSS.n434 VSS.n433 5.2005
R1262 VSS.n575 VSS.n434 5.2005
R1263 VSS.n578 VSS.n577 5.2005
R1264 VSS.n577 VSS.n576 5.2005
R1265 VSS.n579 VSS.n74 5.2005
R1266 VSS.n435 VSS.n74 5.2005
R1267 VSS.n581 VSS.n580 5.2005
R1268 VSS.n582 VSS.n581 5.2005
R1269 VSS.n75 VSS.n73 5.2005
R1270 VSS.n73 VSS.n72 5.2005
R1271 VSS.n427 VSS.n426 5.2005
R1272 VSS.n426 VSS.n425 5.2005
R1273 VSS.n78 VSS.n77 5.2005
R1274 VSS.n79 VSS.n78 5.2005
R1275 VSS.n416 VSS.n415 5.2005
R1276 VSS.n417 VSS.n416 5.2005
R1277 VSS.n86 VSS.n85 5.2005
R1278 VSS.n409 VSS.n85 5.2005
R1279 VSS.n566 VSS.n438 5.2005
R1280 VSS.n574 VSS.n438 5.2005
R1281 VSS.n565 VSS.n437 5.2005
R1282 VSS.n575 VSS.n437 5.2005
R1283 VSS.n564 VSS.n436 5.2005
R1284 VSS.n576 VSS.n436 5.2005
R1285 VSS.n71 VSS.n69 5.2005
R1286 VSS.n435 VSS.n71 5.2005
R1287 VSS.n584 VSS.n583 5.2005
R1288 VSS.n583 VSS.n582 5.2005
R1289 VSS.n70 VSS.n68 5.2005
R1290 VSS.n72 VSS.n70 5.2005
R1291 VSS.n424 VSS.n423 5.2005
R1292 VSS.n425 VSS.n424 5.2005
R1293 VSS.n81 VSS.n80 5.2005
R1294 VSS.n80 VSS.n79 5.2005
R1295 VSS.n419 VSS.n418 5.2005
R1296 VSS.n418 VSS.n417 5.2005
R1297 VSS.n84 VSS.n83 5.2005
R1298 VSS.n409 VSS.n84 5.2005
R1299 VSS.n471 VSS.n470 5.2005
R1300 VSS.n534 VSS.n471 5.2005
R1301 VSS.n537 VSS.n536 5.2005
R1302 VSS.n536 VSS.n535 5.2005
R1303 VSS.n538 VSS.n465 5.2005
R1304 VSS.n465 VSS.n464 5.2005
R1305 VSS.n540 VSS.n539 5.2005
R1306 VSS.n541 VSS.n540 5.2005
R1307 VSS.n460 VSS.n459 5.2005
R1308 VSS.n542 VSS.n460 5.2005
R1309 VSS.n545 VSS.n544 5.2005
R1310 VSS.n544 VSS.n543 5.2005
R1311 VSS.n546 VSS.n452 5.2005
R1312 VSS.n452 VSS.n450 5.2005
R1313 VSS.n548 VSS.n547 5.2005
R1314 VSS.n549 VSS.n548 5.2005
R1315 VSS.n454 VSS.n451 5.2005
R1316 VSS.n451 VSS.n449 5.2005
R1317 VSS.n453 VSS.n440 5.2005
R1318 VSS.n440 VSS.n439 5.2005
R1319 VSS.n527 VSS.n473 5.2005
R1320 VSS.n534 VSS.n473 5.2005
R1321 VSS.n526 VSS.n472 5.2005
R1322 VSS.n535 VSS.n472 5.2005
R1323 VSS.n525 VSS.n524 5.2005
R1324 VSS.n524 VSS.n464 5.2005
R1325 VSS.n516 VSS.n463 5.2005
R1326 VSS.n541 VSS.n463 5.2005
R1327 VSS.n520 VSS.n462 5.2005
R1328 VSS.n542 VSS.n462 5.2005
R1329 VSS.n519 VSS.n461 5.2005
R1330 VSS.n543 VSS.n461 5.2005
R1331 VSS.n448 VSS.n447 5.2005
R1332 VSS.n450 VSS.n448 5.2005
R1333 VSS.n551 VSS.n550 5.2005
R1334 VSS.n550 VSS.n549 5.2005
R1335 VSS.n552 VSS.n445 5.2005
R1336 VSS.n449 VSS.n445 5.2005
R1337 VSS.n553 VSS.n441 5.2005
R1338 VSS.n441 VSS.n439 5.2005
R1339 VSS.n607 VSS.n51 5.2005
R1340 VSS.n51 VSS.n49 5.2005
R1341 VSS.n606 VSS.n605 5.2005
R1342 VSS.n605 VSS.n604 5.2005
R1343 VSS.n55 VSS.n54 5.2005
R1344 VSS.n56 VSS.n55 5.2005
R1345 VSS.n594 VSS.n593 5.2005
R1346 VSS.n595 VSS.n594 5.2005
R1347 VSS.n63 VSS.n62 5.2005
R1348 VSS.n497 VSS.n62 5.2005
R1349 VSS.n496 VSS.n495 5.2005
R1350 VSS.n498 VSS.n496 5.2005
R1351 VSS.n484 VSS.n483 5.2005
R1352 VSS.n486 VSS.n484 5.2005
R1353 VSS.n506 VSS.n505 5.2005
R1354 VSS.n505 VSS.n504 5.2005
R1355 VSS.n507 VSS.n480 5.2005
R1356 VSS.n485 VSS.n480 5.2005
R1357 VSS.n508 VSS.n476 5.2005
R1358 VSS.n476 VSS.n474 5.2005
R1359 VSS.n489 VSS.n475 5.2005
R1360 VSS.n475 VSS.n474 5.2005
R1361 VSS.n490 VSS.n487 5.2005
R1362 VSS.n487 VSS.n485 5.2005
R1363 VSS.n503 VSS.n502 5.2005
R1364 VSS.n504 VSS.n503 5.2005
R1365 VSS.n501 VSS.n488 5.2005
R1366 VSS.n488 VSS.n486 5.2005
R1367 VSS.n500 VSS.n499 5.2005
R1368 VSS.n499 VSS.n498 5.2005
R1369 VSS.n61 VSS.n60 5.2005
R1370 VSS.n497 VSS.n61 5.2005
R1371 VSS.n597 VSS.n596 5.2005
R1372 VSS.n596 VSS.n595 5.2005
R1373 VSS.n58 VSS.n57 5.2005
R1374 VSS.n57 VSS.n56 5.2005
R1375 VSS.n603 VSS.n602 5.2005
R1376 VSS.n604 VSS.n603 5.2005
R1377 VSS.n601 VSS.n50 5.2005
R1378 VSS.n50 VSS.n49 5.2005
R1379 VSS.n838 VSS.n837 5.2005
R1380 VSS.n839 VSS.n838 5.2005
R1381 VSS.n44 VSS.n43 5.2005
R1382 VSS.n840 VSS.n44 5.2005
R1383 VSS.n843 VSS.n842 5.2005
R1384 VSS.n842 VSS.n841 5.2005
R1385 VSS.n844 VSS.n38 5.2005
R1386 VSS.n45 VSS.n38 5.2005
R1387 VSS.n846 VSS.n845 5.2005
R1388 VSS.n847 VSS.n846 5.2005
R1389 VSS.n34 VSS.n33 5.2005
R1390 VSS.n848 VSS.n34 5.2005
R1391 VSS.n851 VSS.n850 5.2005
R1392 VSS.n850 VSS.n849 5.2005
R1393 VSS.n852 VSS.n28 5.2005
R1394 VSS.n28 VSS.n27 5.2005
R1395 VSS.n854 VSS.n853 5.2005
R1396 VSS.n855 VSS.n854 5.2005
R1397 VSS.n23 VSS.n22 5.2005
R1398 VSS.n856 VSS.n23 5.2005
R1399 VSS.n859 VSS.n858 5.2005
R1400 VSS.n858 VSS.n857 5.2005
R1401 VSS.n860 VSS.n17 5.2005
R1402 VSS.n17 VSS.n15 5.2005
R1403 VSS.n862 VSS.n861 5.2005
R1404 VSS.n863 VSS.n862 5.2005
R1405 VSS.n18 VSS.n16 5.2005
R1406 VSS.n16 VSS.n14 5.2005
R1407 VSS.n791 VSS.n784 5.2005
R1408 VSS.n784 VSS.n782 5.2005
R1409 VSS.n793 VSS.n792 5.2005
R1410 VSS.n794 VSS.n793 5.2005
R1411 VSS.n786 VSS.n783 5.2005
R1412 VSS.n783 VSS.n781 5.2005
R1413 VSS.n785 VSS.n772 5.2005
R1414 VSS.n772 VSS.n771 5.2005
R1415 VSS.n831 VSS.n48 5.2005
R1416 VSS.n839 VSS.n48 5.2005
R1417 VSS.n830 VSS.n47 5.2005
R1418 VSS.n840 VSS.n47 5.2005
R1419 VSS.n829 VSS.n46 5.2005
R1420 VSS.n841 VSS.n46 5.2005
R1421 VSS.n811 VSS.n810 5.2005
R1422 VSS.n810 VSS.n45 5.2005
R1423 VSS.n825 VSS.n37 5.2005
R1424 VSS.n847 VSS.n37 5.2005
R1425 VSS.n824 VSS.n36 5.2005
R1426 VSS.n848 VSS.n36 5.2005
R1427 VSS.n823 VSS.n35 5.2005
R1428 VSS.n849 VSS.n35 5.2005
R1429 VSS.n814 VSS.n813 5.2005
R1430 VSS.n813 VSS.n27 5.2005
R1431 VSS.n819 VSS.n26 5.2005
R1432 VSS.n855 VSS.n26 5.2005
R1433 VSS.n818 VSS.n25 5.2005
R1434 VSS.n856 VSS.n25 5.2005
R1435 VSS.n817 VSS.n24 5.2005
R1436 VSS.n857 VSS.n24 5.2005
R1437 VSS.n13 VSS.n11 5.2005
R1438 VSS.n15 VSS.n13 5.2005
R1439 VSS.n865 VSS.n864 5.2005
R1440 VSS.n864 VSS.n863 5.2005
R1441 VSS.n12 VSS.n9 5.2005
R1442 VSS.n14 VSS.n12 5.2005
R1443 VSS.n780 VSS.n779 5.2005
R1444 VSS.n782 VSS.n780 5.2005
R1445 VSS.n796 VSS.n795 5.2005
R1446 VSS.n795 VSS.n794 5.2005
R1447 VSS.n797 VSS.n777 5.2005
R1448 VSS.n781 VSS.n777 5.2005
R1449 VSS.n798 VSS.n773 5.2005
R1450 VSS.n773 VSS.n771 5.2005
R1451 VSS.n625 VSS.n616 5.2005
R1452 VSS.n616 VSS.n615 5.2005
R1453 VSS.n760 VSS.n759 5.2005
R1454 VSS.n761 VSS.n760 5.2005
R1455 VSS.n624 VSS.n623 5.2005
R1456 VSS.n623 VSS.n622 5.2005
R1457 VSS.n755 VSS.n754 5.2005
R1458 VSS.n754 VSS.n753 5.2005
R1459 VSS.n628 VSS.n627 5.2005
R1460 VSS.n629 VSS.n628 5.2005
R1461 VSS.n743 VSS.n742 5.2005
R1462 VSS.n744 VSS.n743 5.2005
R1463 VSS.n637 VSS.n636 5.2005
R1464 VSS.n636 VSS.n635 5.2005
R1465 VSS.n738 VSS.n737 5.2005
R1466 VSS.n737 VSS.n736 5.2005
R1467 VSS.n640 VSS.n639 5.2005
R1468 VSS.n641 VSS.n640 5.2005
R1469 VSS.n727 VSS.n726 5.2005
R1470 VSS.n728 VSS.n727 5.2005
R1471 VSS.n649 VSS.n648 5.2005
R1472 VSS.n648 VSS.n647 5.2005
R1473 VSS.n722 VSS.n721 5.2005
R1474 VSS.n721 VSS.n720 5.2005
R1475 VSS.n652 VSS.n651 5.2005
R1476 VSS.n659 VSS.n652 5.2005
R1477 VSS.n711 VSS.n710 5.2005
R1478 VSS.n712 VSS.n711 5.2005
R1479 VSS.n661 VSS.n660 5.2005
R1480 VSS.n660 VSS.n658 5.2005
R1481 VSS.n706 VSS.n705 5.2005
R1482 VSS.n705 VSS.n704 5.2005
R1483 VSS.n664 VSS.n663 5.2005
R1484 VSS.n671 VSS.n664 5.2005
R1485 VSS.n695 VSS.n694 5.2005
R1486 VSS.n696 VSS.n695 5.2005
R1487 VSS.n673 VSS.n672 5.2005
R1488 VSS.n672 VSS.n670 5.2005
R1489 VSS.n690 VSS.n689 5.2005
R1490 VSS.n689 VSS.n688 5.2005
R1491 VSS.n676 VSS.n675 5.2005
R1492 VSS.n677 VSS.n676 5.2005
R1493 VSS.n764 VSS.n617 5.2005
R1494 VSS.n617 VSS.n615 5.2005
R1495 VSS.n763 VSS.n762 5.2005
R1496 VSS.n762 VSS.n761 5.2005
R1497 VSS.n621 VSS.n620 5.2005
R1498 VSS.n622 VSS.n621 5.2005
R1499 VSS.n752 VSS.n751 5.2005
R1500 VSS.n753 VSS.n752 5.2005
R1501 VSS.n631 VSS.n630 5.2005
R1502 VSS.n630 VSS.n629 5.2005
R1503 VSS.n746 VSS.n745 5.2005
R1504 VSS.n745 VSS.n744 5.2005
R1505 VSS.n634 VSS.n633 5.2005
R1506 VSS.n635 VSS.n634 5.2005
R1507 VSS.n735 VSS.n734 5.2005
R1508 VSS.n736 VSS.n735 5.2005
R1509 VSS.n643 VSS.n642 5.2005
R1510 VSS.n642 VSS.n641 5.2005
R1511 VSS.n730 VSS.n729 5.2005
R1512 VSS.n729 VSS.n728 5.2005
R1513 VSS.n646 VSS.n645 5.2005
R1514 VSS.n647 VSS.n646 5.2005
R1515 VSS.n719 VSS.n718 5.2005
R1516 VSS.n720 VSS.n719 5.2005
R1517 VSS.n654 VSS.n653 5.2005
R1518 VSS.n659 VSS.n653 5.2005
R1519 VSS.n714 VSS.n713 5.2005
R1520 VSS.n713 VSS.n712 5.2005
R1521 VSS.n657 VSS.n656 5.2005
R1522 VSS.n658 VSS.n657 5.2005
R1523 VSS.n703 VSS.n702 5.2005
R1524 VSS.n704 VSS.n703 5.2005
R1525 VSS.n666 VSS.n665 5.2005
R1526 VSS.n671 VSS.n665 5.2005
R1527 VSS.n698 VSS.n697 5.2005
R1528 VSS.n697 VSS.n696 5.2005
R1529 VSS.n669 VSS.n668 5.2005
R1530 VSS.n670 VSS.n669 5.2005
R1531 VSS.n687 VSS.n686 5.2005
R1532 VSS.n688 VSS.n687 5.2005
R1533 VSS.n679 VSS.n678 5.2005
R1534 VSS.n678 VSS.n677 5.2005
R1535 VSS.n767 VSS.n765 5.15464
R1536 VSS.n684 VSS.n683 5.15464
R1537 VSS.n834 VSS.n832 5.14384
R1538 VSS.n800 VSS.n799 5.14384
R1539 VSS.n2 VSS.n1 5.0828
R1540 VSS.n569 VSS.n567 4.92413
R1541 VSS.n88 VSS.n82 4.92413
R1542 VSS.n530 VSS.n528 4.92413
R1543 VSS.n555 VSS.n554 4.92413
R1544 VSS.n510 VSS.n509 4.92413
R1545 VSS.n224 VSS.n223 4.9188
R1546 VSS.n252 VSS.t22 4.83421
R1547 VSS.t19 VSS.n109 4.83421
R1548 VSS.n610 VSS 4.83413
R1549 VSS.n405 VSS 4.8288
R1550 VSS.n2 VSS.n0 4.79367
R1551 VSS.n7 VSS.n6 4.7687
R1552 VSS.n7 VSS.n5 4.74238
R1553 VSS.n587 VSS.n65 4.6562
R1554 VSS.n589 VSS.n588 4.6562
R1555 VSS.n415 VSS.n414 4.5005
R1556 VSS.n77 VSS.n76 4.5005
R1557 VSS.n428 VSS.n427 4.5005
R1558 VSS.n429 VSS.n75 4.5005
R1559 VSS.n580 VSS.n430 4.5005
R1560 VSS.n579 VSS.n431 4.5005
R1561 VSS.n578 VSS.n432 4.5005
R1562 VSS.n561 VSS.n433 4.5005
R1563 VSS.n572 VSS.n571 4.5005
R1564 VSS.n413 VSS.n86 4.5005
R1565 VSS.n420 VSS.n419 4.5005
R1566 VSS.n421 VSS.n81 4.5005
R1567 VSS.n423 VSS.n422 4.5005
R1568 VSS.n68 VSS.n66 4.5005
R1569 VSS.n585 VSS.n584 4.5005
R1570 VSS.n69 VSS.n67 4.5005
R1571 VSS.n564 VSS.n563 4.5005
R1572 VSS.n565 VSS.n562 4.5005
R1573 VSS.n567 VSS.n566 4.5005
R1574 VSS.n83 VSS.n82 4.5005
R1575 VSS.n455 VSS.n454 4.5005
R1576 VSS.n547 VSS.n456 4.5005
R1577 VSS.n546 VSS.n457 4.5005
R1578 VSS.n545 VSS.n458 4.5005
R1579 VSS.n466 VSS.n459 4.5005
R1580 VSS.n539 VSS.n467 4.5005
R1581 VSS.n538 VSS.n468 4.5005
R1582 VSS.n537 VSS.n469 4.5005
R1583 VSS.n514 VSS.n470 4.5005
R1584 VSS.n453 VSS.n442 4.5005
R1585 VSS.n552 VSS.n444 4.5005
R1586 VSS.n551 VSS.n446 4.5005
R1587 VSS.n517 VSS.n447 4.5005
R1588 VSS.n519 VSS.n518 4.5005
R1589 VSS.n521 VSS.n520 4.5005
R1590 VSS.n522 VSS.n516 4.5005
R1591 VSS.n525 VSS.n523 4.5005
R1592 VSS.n526 VSS.n515 4.5005
R1593 VSS.n528 VSS.n527 4.5005
R1594 VSS.n554 VSS.n553 4.5005
R1595 VSS.n489 VSS.n477 4.5005
R1596 VSS.n491 VSS.n490 4.5005
R1597 VSS.n502 VSS.n492 4.5005
R1598 VSS.n501 VSS.n493 4.5005
R1599 VSS.n500 VSS.n494 4.5005
R1600 VSS.n60 VSS.n59 4.5005
R1601 VSS.n598 VSS.n597 4.5005
R1602 VSS.n599 VSS.n58 4.5005
R1603 VSS.n602 VSS.n600 4.5005
R1604 VSS.n601 VSS.n52 4.5005
R1605 VSS.n507 VSS.n479 4.5005
R1606 VSS.n506 VSS.n481 4.5005
R1607 VSS.n483 VSS.n482 4.5005
R1608 VSS.n495 VSS.n64 4.5005
R1609 VSS.n590 VSS.n63 4.5005
R1610 VSS.n593 VSS.n592 4.5005
R1611 VSS.n591 VSS.n54 4.5005
R1612 VSS.n606 VSS.n53 4.5005
R1613 VSS.n608 VSS.n607 4.5005
R1614 VSS.n509 VSS.n508 4.5005
R1615 VSS.n787 VSS.n786 4.5005
R1616 VSS.n792 VSS.n788 4.5005
R1617 VSS.n791 VSS.n790 4.5005
R1618 VSS.n789 VSS.n18 4.5005
R1619 VSS.n861 VSS.n19 4.5005
R1620 VSS.n860 VSS.n20 4.5005
R1621 VSS.n859 VSS.n21 4.5005
R1622 VSS.n29 VSS.n22 4.5005
R1623 VSS.n853 VSS.n30 4.5005
R1624 VSS.n852 VSS.n31 4.5005
R1625 VSS.n851 VSS.n32 4.5005
R1626 VSS.n39 VSS.n33 4.5005
R1627 VSS.n845 VSS.n40 4.5005
R1628 VSS.n844 VSS.n41 4.5005
R1629 VSS.n843 VSS.n42 4.5005
R1630 VSS.n808 VSS.n43 4.5005
R1631 VSS.n837 VSS.n836 4.5005
R1632 VSS.n785 VSS.n774 4.5005
R1633 VSS.n797 VSS.n776 4.5005
R1634 VSS.n796 VSS.n778 4.5005
R1635 VSS.n779 VSS.n8 4.5005
R1636 VSS.n867 VSS.n9 4.5005
R1637 VSS.n866 VSS.n865 4.5005
R1638 VSS.n11 VSS.n10 4.5005
R1639 VSS.n817 VSS.n816 4.5005
R1640 VSS.n818 VSS.n815 4.5005
R1641 VSS.n820 VSS.n819 4.5005
R1642 VSS.n821 VSS.n814 4.5005
R1643 VSS.n823 VSS.n822 4.5005
R1644 VSS.n824 VSS.n812 4.5005
R1645 VSS.n826 VSS.n825 4.5005
R1646 VSS.n827 VSS.n811 4.5005
R1647 VSS.n829 VSS.n828 4.5005
R1648 VSS.n830 VSS.n809 4.5005
R1649 VSS.n832 VSS.n831 4.5005
R1650 VSS.n799 VSS.n798 4.5005
R1651 VSS.n868 VSS.n867 4.5005
R1652 VSS.n155 VSS.n154 4.5005
R1653 VSS.n215 VSS.n214 4.5005
R1654 VSS.n239 VSS.n238 4.5005
R1655 VSS.n240 VSS.n213 4.5005
R1656 VSS.n242 VSS.n241 4.5005
R1657 VSS.n203 VSS.n202 4.5005
R1658 VSS.n255 VSS.n254 4.5005
R1659 VSS.n256 VSS.n201 4.5005
R1660 VSS.n258 VSS.n257 4.5005
R1661 VSS.n191 VSS.n190 4.5005
R1662 VSS.n271 VSS.n270 4.5005
R1663 VSS.n272 VSS.n189 4.5005
R1664 VSS.n274 VSS.n273 4.5005
R1665 VSS.n179 VSS.n178 4.5005
R1666 VSS.n287 VSS.n286 4.5005
R1667 VSS.n288 VSS.n177 4.5005
R1668 VSS.n290 VSS.n289 4.5005
R1669 VSS.n167 VSS.n166 4.5005
R1670 VSS.n303 VSS.n302 4.5005
R1671 VSS.n304 VSS.n165 4.5005
R1672 VSS.n307 VSS.n306 4.5005
R1673 VSS.n305 VSS.n156 4.5005
R1674 VSS.n321 VSS.n320 4.5005
R1675 VSS.n322 VSS.n153 4.5005
R1676 VSS.n324 VSS.n323 4.5005
R1677 VSS.n143 VSS.n142 4.5005
R1678 VSS.n337 VSS.n336 4.5005
R1679 VSS.n338 VSS.n141 4.5005
R1680 VSS.n340 VSS.n339 4.5005
R1681 VSS.n131 VSS.n130 4.5005
R1682 VSS.n353 VSS.n352 4.5005
R1683 VSS.n354 VSS.n129 4.5005
R1684 VSS.n356 VSS.n355 4.5005
R1685 VSS.n119 VSS.n118 4.5005
R1686 VSS.n369 VSS.n368 4.5005
R1687 VSS.n370 VSS.n117 4.5005
R1688 VSS.n372 VSS.n371 4.5005
R1689 VSS.n107 VSS.n106 4.5005
R1690 VSS.n385 VSS.n384 4.5005
R1691 VSS.n386 VSS.n105 4.5005
R1692 VSS.n389 VSS.n388 4.5005
R1693 VSS.n387 VSS.n95 4.5005
R1694 VSS.n402 VSS.n94 4.5005
R1695 VSS.n404 VSS.n403 4.5005
R1696 VSS.n225 VSS.n224 4.5005
R1697 VSS.n232 VSS.n219 4.5005
R1698 VSS.n234 VSS.n233 4.5005
R1699 VSS.n209 VSS.n208 4.5005
R1700 VSS.n247 VSS.n246 4.5005
R1701 VSS.n248 VSS.n207 4.5005
R1702 VSS.n250 VSS.n249 4.5005
R1703 VSS.n197 VSS.n196 4.5005
R1704 VSS.n263 VSS.n262 4.5005
R1705 VSS.n264 VSS.n195 4.5005
R1706 VSS.n266 VSS.n265 4.5005
R1707 VSS.n185 VSS.n184 4.5005
R1708 VSS.n279 VSS.n278 4.5005
R1709 VSS.n280 VSS.n183 4.5005
R1710 VSS.n282 VSS.n281 4.5005
R1711 VSS.n173 VSS.n172 4.5005
R1712 VSS.n295 VSS.n294 4.5005
R1713 VSS.n296 VSS.n171 4.5005
R1714 VSS.n298 VSS.n297 4.5005
R1715 VSS.n161 VSS.n160 4.5005
R1716 VSS.n313 VSS.n312 4.5005
R1717 VSS.n314 VSS.n159 4.5005
R1718 VSS.n316 VSS.n315 4.5005
R1719 VSS.n149 VSS.n148 4.5005
R1720 VSS.n329 VSS.n328 4.5005
R1721 VSS.n330 VSS.n147 4.5005
R1722 VSS.n332 VSS.n331 4.5005
R1723 VSS.n137 VSS.n136 4.5005
R1724 VSS.n345 VSS.n344 4.5005
R1725 VSS.n346 VSS.n135 4.5005
R1726 VSS.n348 VSS.n347 4.5005
R1727 VSS.n125 VSS.n124 4.5005
R1728 VSS.n361 VSS.n360 4.5005
R1729 VSS.n362 VSS.n123 4.5005
R1730 VSS.n364 VSS.n363 4.5005
R1731 VSS.n113 VSS.n112 4.5005
R1732 VSS.n377 VSS.n376 4.5005
R1733 VSS.n378 VSS.n111 4.5005
R1734 VSS.n380 VSS.n379 4.5005
R1735 VSS.n101 VSS.n100 4.5005
R1736 VSS.n394 VSS.n393 4.5005
R1737 VSS.n395 VSS.n99 4.5005
R1738 VSS.n398 VSS.n396 4.5005
R1739 VSS.n397 VSS.n92 4.5005
R1740 VSS.n231 VSS.n230 4.5005
R1741 VSS.n691 VSS.n690 4.5005
R1742 VSS.n692 VSS.n673 4.5005
R1743 VSS.n694 VSS.n693 4.5005
R1744 VSS.n663 VSS.n662 4.5005
R1745 VSS.n707 VSS.n706 4.5005
R1746 VSS.n708 VSS.n661 4.5005
R1747 VSS.n710 VSS.n709 4.5005
R1748 VSS.n651 VSS.n650 4.5005
R1749 VSS.n723 VSS.n722 4.5005
R1750 VSS.n724 VSS.n649 4.5005
R1751 VSS.n726 VSS.n725 4.5005
R1752 VSS.n639 VSS.n638 4.5005
R1753 VSS.n739 VSS.n738 4.5005
R1754 VSS.n740 VSS.n637 4.5005
R1755 VSS.n742 VSS.n741 4.5005
R1756 VSS.n627 VSS.n626 4.5005
R1757 VSS.n756 VSS.n755 4.5005
R1758 VSS.n757 VSS.n624 4.5005
R1759 VSS.n759 VSS.n758 4.5005
R1760 VSS.n625 VSS.n618 4.5005
R1761 VSS.n675 VSS.n674 4.5005
R1762 VSS.n686 VSS.n685 4.5005
R1763 VSS.n668 VSS.n667 4.5005
R1764 VSS.n699 VSS.n698 4.5005
R1765 VSS.n700 VSS.n666 4.5005
R1766 VSS.n702 VSS.n701 4.5005
R1767 VSS.n656 VSS.n655 4.5005
R1768 VSS.n715 VSS.n714 4.5005
R1769 VSS.n716 VSS.n654 4.5005
R1770 VSS.n718 VSS.n717 4.5005
R1771 VSS.n645 VSS.n644 4.5005
R1772 VSS.n731 VSS.n730 4.5005
R1773 VSS.n732 VSS.n643 4.5005
R1774 VSS.n734 VSS.n733 4.5005
R1775 VSS.n633 VSS.n632 4.5005
R1776 VSS.n747 VSS.n746 4.5005
R1777 VSS.n748 VSS.n631 4.5005
R1778 VSS.n751 VSS.n750 4.5005
R1779 VSS.n749 VSS.n620 4.5005
R1780 VSS.n763 VSS.n619 4.5005
R1781 VSS.n765 VSS.n764 4.5005
R1782 VSS.n684 VSS.n679 4.5005
R1783 VSS.n701 VSS.n3 4.5005
R1784 VSS.t54 VSS.n14 4.27696
R1785 VSS.n847 VSS.t56 4.27696
R1786 VSS.n93 VSS.t20 4.10539
R1787 VSS.n222 VSS.t23 4.10539
R1788 VSS.n227 VSS.n226 3.93276
R1789 VSS.n659 VSS.t50 2.74182
R1790 VSS.t38 VSS.n641 2.74182
R1791 VSS.t43 VSS.n72 2.28309
R1792 VSS.n582 VSS.t42 2.28309
R1793 VSS.n543 VSS.t37 2.28309
R1794 VSS.n542 VSS.t36 2.28309
R1795 VSS.n498 VSS.t45 2.28309
R1796 VSS.n497 VSS.t44 2.28309
R1797 VSS.n870 VSS 1.91068
R1798 VSS.n766 VSS.t32 1.6133
R1799 VSS.n682 VSS.t35 1.6133
R1800 VSS.n871 VSS.n870 1.57978
R1801 VSS.n857 VSS.t58 1.42599
R1802 VSS.t52 VSS.n27 1.42599
R1803 VSS.n833 VSS.t26 1.25272
R1804 VSS.n775 VSS.t29 1.25272
R1805 VSS.n568 VSS.t14 1.00876
R1806 VSS.n87 VSS.t17 1.00876
R1807 VSS.n529 VSS.t8 1.00876
R1808 VSS.n443 VSS.t11 1.00876
R1809 VSS.n609 VSS.t2 1.00876
R1810 VSS.n478 VSS.t5 1.00876
R1811 VSS.n228 VSS.n227 0.985442
R1812 VSS.n871 VSS.n4 0.960575
R1813 VSS.n588 VSS.n587 0.8456
R1814 VSS.n868 VSS.n7 0.819238
R1815 VSS.n405 VSS.n93 0.689677
R1816 VSS.n223 VSS.n222 0.689677
R1817 VSS.n221 VSS.n220 0.6505
R1818 VSS.n407 VSS.n406 0.6505
R1819 VSS.n408 VSS.n407 0.6505
R1820 VSS.n3 VSS.n2 0.624629
R1821 VSS.n835 VSS.n834 0.522891
R1822 VSS.n801 VSS.n800 0.522891
R1823 VSS.n570 VSS.n569 0.518
R1824 VSS.n412 VSS.n88 0.518
R1825 VSS.n531 VSS.n530 0.518
R1826 VSS.n556 VSS.n555 0.518
R1827 VSS.n611 VSS.n610 0.518
R1828 VSS.n511 VSS.n510 0.518
R1829 VSS.n768 VSS.n767 0.425065
R1830 VSS.n683 VSS.n681 0.425065
R1831 VSS.n412 VSS.n411 0.371929
R1832 VSS.n411 VSS.n410 0.371929
R1833 VSS.n570 VSS.n560 0.371929
R1834 VSS.n560 VSS.n559 0.371929
R1835 VSS.n557 VSS.n556 0.371929
R1836 VSS.n558 VSS.n557 0.371929
R1837 VSS.n532 VSS.n531 0.371929
R1838 VSS.n533 VSS.n532 0.371929
R1839 VSS.n512 VSS.n511 0.371929
R1840 VSS.n513 VSS.n512 0.371929
R1841 VSS.n612 VSS.n611 0.371929
R1842 VSS.n613 VSS.n612 0.371929
R1843 VSS.n767 VSS.n766 0.302769
R1844 VSS.n683 VSS.n682 0.302769
R1845 VSS.n769 VSS.n768 0.289389
R1846 VSS.n770 VSS.n769 0.289389
R1847 VSS.n681 VSS.n680 0.289389
R1848 VSS.n680 VSS.n614 0.289389
R1849 VSS.n834 VSS.n833 0.283296
R1850 VSS.n800 VSS.n775 0.283296
R1851 VSS.n569 VSS.n568 0.28275
R1852 VSS.n88 VSS.n87 0.28275
R1853 VSS.n530 VSS.n529 0.28275
R1854 VSS.n555 VSS.n443 0.28275
R1855 VSS.n610 VSS.n609 0.28275
R1856 VSS.n510 VSS.n478 0.28275
R1857 VSS.n802 VSS.n801 0.2605
R1858 VSS.n803 VSS.n802 0.2605
R1859 VSS.n835 VSS.n807 0.2605
R1860 VSS.n807 VSS.n806 0.2605
R1861 VSS.n406 VSS.n405 0.224522
R1862 VSS.n223 VSS.n220 0.224522
R1863 VSS.n686 VSS.n679 0.1445
R1864 VSS.n686 VSS.n668 0.1445
R1865 VSS.n698 VSS.n668 0.1445
R1866 VSS.n698 VSS.n666 0.1445
R1867 VSS.n702 VSS.n666 0.1445
R1868 VSS.n702 VSS.n656 0.1445
R1869 VSS.n714 VSS.n656 0.1445
R1870 VSS.n714 VSS.n654 0.1445
R1871 VSS.n718 VSS.n654 0.1445
R1872 VSS.n718 VSS.n645 0.1445
R1873 VSS.n730 VSS.n645 0.1445
R1874 VSS.n730 VSS.n643 0.1445
R1875 VSS.n734 VSS.n643 0.1445
R1876 VSS.n734 VSS.n633 0.1445
R1877 VSS.n746 VSS.n633 0.1445
R1878 VSS.n746 VSS.n631 0.1445
R1879 VSS.n751 VSS.n631 0.1445
R1880 VSS.n751 VSS.n620 0.1445
R1881 VSS.n763 VSS.n620 0.1445
R1882 VSS.n764 VSS.n763 0.1445
R1883 VSS.n225 VSS.n215 0.1445
R1884 VSS.n238 VSS.n215 0.1445
R1885 VSS.n238 VSS.n213 0.1445
R1886 VSS.n242 VSS.n213 0.1445
R1887 VSS.n242 VSS.n203 0.1445
R1888 VSS.n254 VSS.n203 0.1445
R1889 VSS.n254 VSS.n201 0.1445
R1890 VSS.n258 VSS.n201 0.1445
R1891 VSS.n258 VSS.n191 0.1445
R1892 VSS.n270 VSS.n191 0.1445
R1893 VSS.n270 VSS.n189 0.1445
R1894 VSS.n274 VSS.n189 0.1445
R1895 VSS.n274 VSS.n179 0.1445
R1896 VSS.n286 VSS.n179 0.1445
R1897 VSS.n286 VSS.n177 0.1445
R1898 VSS.n290 VSS.n177 0.1445
R1899 VSS.n290 VSS.n167 0.1445
R1900 VSS.n302 VSS.n167 0.1445
R1901 VSS.n302 VSS.n165 0.1445
R1902 VSS.n307 VSS.n165 0.1445
R1903 VSS.n307 VSS.n156 0.1445
R1904 VSS.n320 VSS.n156 0.1445
R1905 VSS.n320 VSS.n153 0.1445
R1906 VSS.n324 VSS.n153 0.1445
R1907 VSS.n324 VSS.n143 0.1445
R1908 VSS.n336 VSS.n143 0.1445
R1909 VSS.n336 VSS.n141 0.1445
R1910 VSS.n340 VSS.n141 0.1445
R1911 VSS.n340 VSS.n131 0.1445
R1912 VSS.n352 VSS.n131 0.1445
R1913 VSS.n352 VSS.n129 0.1445
R1914 VSS.n356 VSS.n129 0.1445
R1915 VSS.n356 VSS.n119 0.1445
R1916 VSS.n368 VSS.n119 0.1445
R1917 VSS.n368 VSS.n117 0.1445
R1918 VSS.n372 VSS.n117 0.1445
R1919 VSS.n372 VSS.n107 0.1445
R1920 VSS.n384 VSS.n107 0.1445
R1921 VSS.n384 VSS.n105 0.1445
R1922 VSS.n389 VSS.n105 0.1445
R1923 VSS.n389 VSS.n95 0.1445
R1924 VSS.n402 VSS.n95 0.1445
R1925 VSS.n403 VSS.n402 0.1445
R1926 VSS.n419 VSS.n83 0.1445
R1927 VSS.n419 VSS.n81 0.1445
R1928 VSS.n423 VSS.n81 0.1445
R1929 VSS.n423 VSS.n68 0.1445
R1930 VSS.n584 VSS.n68 0.1445
R1931 VSS.n584 VSS.n69 0.1445
R1932 VSS.n564 VSS.n69 0.1445
R1933 VSS.n565 VSS.n564 0.1445
R1934 VSS.n566 VSS.n565 0.1445
R1935 VSS.n415 VSS.n86 0.1445
R1936 VSS.n415 VSS.n77 0.1445
R1937 VSS.n427 VSS.n77 0.1445
R1938 VSS.n427 VSS.n75 0.1445
R1939 VSS.n580 VSS.n75 0.1445
R1940 VSS.n580 VSS.n579 0.1445
R1941 VSS.n579 VSS.n578 0.1445
R1942 VSS.n578 VSS.n433 0.1445
R1943 VSS.n572 VSS.n433 0.1445
R1944 VSS.n414 VSS.n413 0.1445
R1945 VSS.n414 VSS.n76 0.1445
R1946 VSS.n428 VSS.n76 0.1445
R1947 VSS.n429 VSS.n428 0.1445
R1948 VSS.n430 VSS.n429 0.1445
R1949 VSS.n431 VSS.n430 0.1445
R1950 VSS.n432 VSS.n431 0.1445
R1951 VSS.n561 VSS.n432 0.1445
R1952 VSS.n571 VSS.n561 0.1445
R1953 VSS.n420 VSS.n82 0.1445
R1954 VSS.n421 VSS.n420 0.1445
R1955 VSS.n422 VSS.n421 0.1445
R1956 VSS.n422 VSS.n66 0.1445
R1957 VSS.n585 VSS.n67 0.1445
R1958 VSS.n563 VSS.n67 0.1445
R1959 VSS.n563 VSS.n562 0.1445
R1960 VSS.n567 VSS.n562 0.1445
R1961 VSS.n553 VSS.n552 0.1445
R1962 VSS.n552 VSS.n551 0.1445
R1963 VSS.n551 VSS.n447 0.1445
R1964 VSS.n519 VSS.n447 0.1445
R1965 VSS.n520 VSS.n519 0.1445
R1966 VSS.n520 VSS.n516 0.1445
R1967 VSS.n525 VSS.n516 0.1445
R1968 VSS.n526 VSS.n525 0.1445
R1969 VSS.n527 VSS.n526 0.1445
R1970 VSS.n454 VSS.n453 0.1445
R1971 VSS.n547 VSS.n454 0.1445
R1972 VSS.n547 VSS.n546 0.1445
R1973 VSS.n546 VSS.n545 0.1445
R1974 VSS.n545 VSS.n459 0.1445
R1975 VSS.n539 VSS.n459 0.1445
R1976 VSS.n539 VSS.n538 0.1445
R1977 VSS.n538 VSS.n537 0.1445
R1978 VSS.n537 VSS.n470 0.1445
R1979 VSS.n455 VSS.n442 0.1445
R1980 VSS.n456 VSS.n455 0.1445
R1981 VSS.n457 VSS.n456 0.1445
R1982 VSS.n458 VSS.n457 0.1445
R1983 VSS.n466 VSS.n458 0.1445
R1984 VSS.n467 VSS.n466 0.1445
R1985 VSS.n468 VSS.n467 0.1445
R1986 VSS.n469 VSS.n468 0.1445
R1987 VSS.n514 VSS.n469 0.1445
R1988 VSS.n554 VSS.n444 0.1445
R1989 VSS.n446 VSS.n444 0.1445
R1990 VSS.n517 VSS.n446 0.1445
R1991 VSS.n518 VSS.n517 0.1445
R1992 VSS.n522 VSS.n521 0.1445
R1993 VSS.n523 VSS.n522 0.1445
R1994 VSS.n523 VSS.n515 0.1445
R1995 VSS.n528 VSS.n515 0.1445
R1996 VSS.n508 VSS.n507 0.1445
R1997 VSS.n507 VSS.n506 0.1445
R1998 VSS.n506 VSS.n483 0.1445
R1999 VSS.n495 VSS.n483 0.1445
R2000 VSS.n495 VSS.n63 0.1445
R2001 VSS.n593 VSS.n63 0.1445
R2002 VSS.n593 VSS.n54 0.1445
R2003 VSS.n606 VSS.n54 0.1445
R2004 VSS.n607 VSS.n606 0.1445
R2005 VSS.n490 VSS.n489 0.1445
R2006 VSS.n502 VSS.n490 0.1445
R2007 VSS.n502 VSS.n501 0.1445
R2008 VSS.n501 VSS.n500 0.1445
R2009 VSS.n500 VSS.n60 0.1445
R2010 VSS.n597 VSS.n60 0.1445
R2011 VSS.n597 VSS.n58 0.1445
R2012 VSS.n602 VSS.n58 0.1445
R2013 VSS.n602 VSS.n601 0.1445
R2014 VSS.n491 VSS.n477 0.1445
R2015 VSS.n492 VSS.n491 0.1445
R2016 VSS.n493 VSS.n492 0.1445
R2017 VSS.n494 VSS.n493 0.1445
R2018 VSS.n494 VSS.n59 0.1445
R2019 VSS.n598 VSS.n59 0.1445
R2020 VSS.n599 VSS.n598 0.1445
R2021 VSS.n600 VSS.n599 0.1445
R2022 VSS.n600 VSS.n52 0.1445
R2023 VSS.n509 VSS.n479 0.1445
R2024 VSS.n481 VSS.n479 0.1445
R2025 VSS.n482 VSS.n481 0.1445
R2026 VSS.n482 VSS.n64 0.1445
R2027 VSS.n592 VSS.n590 0.1445
R2028 VSS.n592 VSS.n591 0.1445
R2029 VSS.n591 VSS.n53 0.1445
R2030 VSS.n608 VSS.n53 0.1445
R2031 VSS.n798 VSS.n797 0.1445
R2032 VSS.n797 VSS.n796 0.1445
R2033 VSS.n796 VSS.n779 0.1445
R2034 VSS.n779 VSS.n9 0.1445
R2035 VSS.n865 VSS.n9 0.1445
R2036 VSS.n865 VSS.n11 0.1445
R2037 VSS.n817 VSS.n11 0.1445
R2038 VSS.n818 VSS.n817 0.1445
R2039 VSS.n819 VSS.n818 0.1445
R2040 VSS.n819 VSS.n814 0.1445
R2041 VSS.n823 VSS.n814 0.1445
R2042 VSS.n824 VSS.n823 0.1445
R2043 VSS.n825 VSS.n824 0.1445
R2044 VSS.n825 VSS.n811 0.1445
R2045 VSS.n829 VSS.n811 0.1445
R2046 VSS.n830 VSS.n829 0.1445
R2047 VSS.n831 VSS.n830 0.1445
R2048 VSS.n786 VSS.n785 0.1445
R2049 VSS.n792 VSS.n786 0.1445
R2050 VSS.n792 VSS.n791 0.1445
R2051 VSS.n791 VSS.n18 0.1445
R2052 VSS.n861 VSS.n18 0.1445
R2053 VSS.n861 VSS.n860 0.1445
R2054 VSS.n860 VSS.n859 0.1445
R2055 VSS.n859 VSS.n22 0.1445
R2056 VSS.n853 VSS.n22 0.1445
R2057 VSS.n853 VSS.n852 0.1445
R2058 VSS.n852 VSS.n851 0.1445
R2059 VSS.n851 VSS.n33 0.1445
R2060 VSS.n845 VSS.n33 0.1445
R2061 VSS.n845 VSS.n844 0.1445
R2062 VSS.n844 VSS.n843 0.1445
R2063 VSS.n843 VSS.n43 0.1445
R2064 VSS.n837 VSS.n43 0.1445
R2065 VSS.n787 VSS.n774 0.1445
R2066 VSS.n788 VSS.n787 0.1445
R2067 VSS.n790 VSS.n788 0.1445
R2068 VSS.n790 VSS.n789 0.1445
R2069 VSS.n789 VSS.n19 0.1445
R2070 VSS.n20 VSS.n19 0.1445
R2071 VSS.n21 VSS.n20 0.1445
R2072 VSS.n29 VSS.n21 0.1445
R2073 VSS.n30 VSS.n29 0.1445
R2074 VSS.n31 VSS.n30 0.1445
R2075 VSS.n32 VSS.n31 0.1445
R2076 VSS.n39 VSS.n32 0.1445
R2077 VSS.n40 VSS.n39 0.1445
R2078 VSS.n41 VSS.n40 0.1445
R2079 VSS.n42 VSS.n41 0.1445
R2080 VSS.n808 VSS.n42 0.1445
R2081 VSS.n836 VSS.n808 0.1445
R2082 VSS.n799 VSS.n776 0.1445
R2083 VSS.n778 VSS.n776 0.1445
R2084 VSS.n778 VSS.n8 0.1445
R2085 VSS.n867 VSS.n8 0.1445
R2086 VSS.n867 VSS.n866 0.1445
R2087 VSS.n866 VSS.n10 0.1445
R2088 VSS.n816 VSS.n10 0.1445
R2089 VSS.n816 VSS.n815 0.1445
R2090 VSS.n820 VSS.n815 0.1445
R2091 VSS.n821 VSS.n820 0.1445
R2092 VSS.n822 VSS.n821 0.1445
R2093 VSS.n822 VSS.n812 0.1445
R2094 VSS.n826 VSS.n812 0.1445
R2095 VSS.n827 VSS.n826 0.1445
R2096 VSS.n828 VSS.n827 0.1445
R2097 VSS.n828 VSS.n809 0.1445
R2098 VSS.n832 VSS.n809 0.1445
R2099 VSS.n224 VSS.n214 0.1445
R2100 VSS.n239 VSS.n214 0.1445
R2101 VSS.n240 VSS.n239 0.1445
R2102 VSS.n241 VSS.n240 0.1445
R2103 VSS.n241 VSS.n202 0.1445
R2104 VSS.n255 VSS.n202 0.1445
R2105 VSS.n256 VSS.n255 0.1445
R2106 VSS.n257 VSS.n256 0.1445
R2107 VSS.n257 VSS.n190 0.1445
R2108 VSS.n271 VSS.n190 0.1445
R2109 VSS.n272 VSS.n271 0.1445
R2110 VSS.n273 VSS.n272 0.1445
R2111 VSS.n273 VSS.n178 0.1445
R2112 VSS.n287 VSS.n178 0.1445
R2113 VSS.n288 VSS.n287 0.1445
R2114 VSS.n289 VSS.n288 0.1445
R2115 VSS.n289 VSS.n166 0.1445
R2116 VSS.n303 VSS.n166 0.1445
R2117 VSS.n304 VSS.n303 0.1445
R2118 VSS.n306 VSS.n304 0.1445
R2119 VSS.n306 VSS.n305 0.1445
R2120 VSS.n322 VSS.n321 0.1445
R2121 VSS.n323 VSS.n322 0.1445
R2122 VSS.n323 VSS.n142 0.1445
R2123 VSS.n337 VSS.n142 0.1445
R2124 VSS.n338 VSS.n337 0.1445
R2125 VSS.n339 VSS.n338 0.1445
R2126 VSS.n339 VSS.n130 0.1445
R2127 VSS.n353 VSS.n130 0.1445
R2128 VSS.n354 VSS.n353 0.1445
R2129 VSS.n355 VSS.n354 0.1445
R2130 VSS.n355 VSS.n118 0.1445
R2131 VSS.n369 VSS.n118 0.1445
R2132 VSS.n370 VSS.n369 0.1445
R2133 VSS.n371 VSS.n370 0.1445
R2134 VSS.n371 VSS.n106 0.1445
R2135 VSS.n385 VSS.n106 0.1445
R2136 VSS.n386 VSS.n385 0.1445
R2137 VSS.n388 VSS.n386 0.1445
R2138 VSS.n388 VSS.n387 0.1445
R2139 VSS.n387 VSS.n94 0.1445
R2140 VSS.n404 VSS.n94 0.1445
R2141 VSS.n232 VSS.n231 0.1445
R2142 VSS.n233 VSS.n232 0.1445
R2143 VSS.n233 VSS.n208 0.1445
R2144 VSS.n247 VSS.n208 0.1445
R2145 VSS.n248 VSS.n247 0.1445
R2146 VSS.n249 VSS.n248 0.1445
R2147 VSS.n249 VSS.n196 0.1445
R2148 VSS.n263 VSS.n196 0.1445
R2149 VSS.n264 VSS.n263 0.1445
R2150 VSS.n265 VSS.n264 0.1445
R2151 VSS.n265 VSS.n184 0.1445
R2152 VSS.n279 VSS.n184 0.1445
R2153 VSS.n280 VSS.n279 0.1445
R2154 VSS.n281 VSS.n280 0.1445
R2155 VSS.n281 VSS.n172 0.1445
R2156 VSS.n295 VSS.n172 0.1445
R2157 VSS.n296 VSS.n295 0.1445
R2158 VSS.n297 VSS.n296 0.1445
R2159 VSS.n297 VSS.n160 0.1445
R2160 VSS.n313 VSS.n160 0.1445
R2161 VSS.n314 VSS.n313 0.1445
R2162 VSS.n315 VSS.n314 0.1445
R2163 VSS.n315 VSS.n148 0.1445
R2164 VSS.n329 VSS.n148 0.1445
R2165 VSS.n330 VSS.n329 0.1445
R2166 VSS.n331 VSS.n330 0.1445
R2167 VSS.n331 VSS.n136 0.1445
R2168 VSS.n345 VSS.n136 0.1445
R2169 VSS.n346 VSS.n345 0.1445
R2170 VSS.n347 VSS.n346 0.1445
R2171 VSS.n347 VSS.n124 0.1445
R2172 VSS.n361 VSS.n124 0.1445
R2173 VSS.n362 VSS.n361 0.1445
R2174 VSS.n363 VSS.n362 0.1445
R2175 VSS.n363 VSS.n112 0.1445
R2176 VSS.n377 VSS.n112 0.1445
R2177 VSS.n378 VSS.n377 0.1445
R2178 VSS.n379 VSS.n378 0.1445
R2179 VSS.n379 VSS.n100 0.1445
R2180 VSS.n394 VSS.n100 0.1445
R2181 VSS.n395 VSS.n394 0.1445
R2182 VSS.n396 VSS.n395 0.1445
R2183 VSS.n396 VSS.n92 0.1445
R2184 VSS.n230 VSS.n219 0.1445
R2185 VSS.n234 VSS.n219 0.1445
R2186 VSS.n234 VSS.n209 0.1445
R2187 VSS.n246 VSS.n209 0.1445
R2188 VSS.n246 VSS.n207 0.1445
R2189 VSS.n250 VSS.n207 0.1445
R2190 VSS.n250 VSS.n197 0.1445
R2191 VSS.n262 VSS.n197 0.1445
R2192 VSS.n262 VSS.n195 0.1445
R2193 VSS.n266 VSS.n195 0.1445
R2194 VSS.n266 VSS.n185 0.1445
R2195 VSS.n278 VSS.n185 0.1445
R2196 VSS.n278 VSS.n183 0.1445
R2197 VSS.n282 VSS.n183 0.1445
R2198 VSS.n282 VSS.n173 0.1445
R2199 VSS.n294 VSS.n173 0.1445
R2200 VSS.n294 VSS.n171 0.1445
R2201 VSS.n298 VSS.n171 0.1445
R2202 VSS.n298 VSS.n161 0.1445
R2203 VSS.n312 VSS.n161 0.1445
R2204 VSS.n312 VSS.n159 0.1445
R2205 VSS.n316 VSS.n159 0.1445
R2206 VSS.n316 VSS.n149 0.1445
R2207 VSS.n328 VSS.n149 0.1445
R2208 VSS.n328 VSS.n147 0.1445
R2209 VSS.n332 VSS.n147 0.1445
R2210 VSS.n332 VSS.n137 0.1445
R2211 VSS.n344 VSS.n137 0.1445
R2212 VSS.n344 VSS.n135 0.1445
R2213 VSS.n348 VSS.n135 0.1445
R2214 VSS.n348 VSS.n125 0.1445
R2215 VSS.n360 VSS.n125 0.1445
R2216 VSS.n360 VSS.n123 0.1445
R2217 VSS.n364 VSS.n123 0.1445
R2218 VSS.n364 VSS.n113 0.1445
R2219 VSS.n376 VSS.n113 0.1445
R2220 VSS.n376 VSS.n111 0.1445
R2221 VSS.n380 VSS.n111 0.1445
R2222 VSS.n380 VSS.n101 0.1445
R2223 VSS.n393 VSS.n101 0.1445
R2224 VSS.n393 VSS.n99 0.1445
R2225 VSS.n398 VSS.n99 0.1445
R2226 VSS.n398 VSS.n397 0.1445
R2227 VSS.n690 VSS.n675 0.1445
R2228 VSS.n690 VSS.n673 0.1445
R2229 VSS.n694 VSS.n673 0.1445
R2230 VSS.n694 VSS.n663 0.1445
R2231 VSS.n706 VSS.n663 0.1445
R2232 VSS.n706 VSS.n661 0.1445
R2233 VSS.n710 VSS.n661 0.1445
R2234 VSS.n710 VSS.n651 0.1445
R2235 VSS.n722 VSS.n651 0.1445
R2236 VSS.n722 VSS.n649 0.1445
R2237 VSS.n726 VSS.n649 0.1445
R2238 VSS.n726 VSS.n639 0.1445
R2239 VSS.n738 VSS.n639 0.1445
R2240 VSS.n738 VSS.n637 0.1445
R2241 VSS.n742 VSS.n637 0.1445
R2242 VSS.n742 VSS.n627 0.1445
R2243 VSS.n755 VSS.n627 0.1445
R2244 VSS.n755 VSS.n624 0.1445
R2245 VSS.n759 VSS.n624 0.1445
R2246 VSS.n759 VSS.n625 0.1445
R2247 VSS.n691 VSS.n674 0.1445
R2248 VSS.n692 VSS.n691 0.1445
R2249 VSS.n693 VSS.n692 0.1445
R2250 VSS.n693 VSS.n662 0.1445
R2251 VSS.n707 VSS.n662 0.1445
R2252 VSS.n708 VSS.n707 0.1445
R2253 VSS.n709 VSS.n708 0.1445
R2254 VSS.n709 VSS.n650 0.1445
R2255 VSS.n723 VSS.n650 0.1445
R2256 VSS.n724 VSS.n723 0.1445
R2257 VSS.n725 VSS.n724 0.1445
R2258 VSS.n725 VSS.n638 0.1445
R2259 VSS.n739 VSS.n638 0.1445
R2260 VSS.n740 VSS.n739 0.1445
R2261 VSS.n741 VSS.n740 0.1445
R2262 VSS.n741 VSS.n626 0.1445
R2263 VSS.n756 VSS.n626 0.1445
R2264 VSS.n757 VSS.n756 0.1445
R2265 VSS.n758 VSS.n757 0.1445
R2266 VSS.n758 VSS.n618 0.1445
R2267 VSS.n685 VSS.n684 0.1445
R2268 VSS.n685 VSS.n667 0.1445
R2269 VSS.n699 VSS.n667 0.1445
R2270 VSS.n700 VSS.n699 0.1445
R2271 VSS.n701 VSS.n700 0.1445
R2272 VSS.n701 VSS.n655 0.1445
R2273 VSS.n715 VSS.n655 0.1445
R2274 VSS.n716 VSS.n715 0.1445
R2275 VSS.n717 VSS.n716 0.1445
R2276 VSS.n717 VSS.n644 0.1445
R2277 VSS.n731 VSS.n644 0.1445
R2278 VSS.n732 VSS.n731 0.1445
R2279 VSS.n733 VSS.n732 0.1445
R2280 VSS.n733 VSS.n632 0.1445
R2281 VSS.n747 VSS.n632 0.1445
R2282 VSS.n748 VSS.n747 0.1445
R2283 VSS.n750 VSS.n748 0.1445
R2284 VSS.n750 VSS.n749 0.1445
R2285 VSS.n749 VSS.n619 0.1445
R2286 VSS.n765 VSS.n619 0.1445
R2287 VSS VSS.n608 0.0905
R2288 VSS VSS.n404 0.0905
R2289 VSS.n586 VSS.n66 0.0725
R2290 VSS.n586 VSS.n585 0.0725
R2291 VSS.n518 VSS.n65 0.0725
R2292 VSS.n521 VSS.n65 0.0725
R2293 VSS.n589 VSS.n64 0.0725
R2294 VSS.n590 VSS.n589 0.0725
R2295 VSS.n305 VSS.n155 0.0725
R2296 VSS.n321 VSS.n155 0.0725
R2297 VSS.n872 VSS.n3 0.0418793
R2298 VSS.n869 VSS.n868 0.0339884
R2299 VSS VSS.n869 0.017375
R2300 VSS.n872 VSS 0.017375
R2301 VSS VSS.n872 0.0160172
R2302 VSS.n869 VSS 0.0130581
C0 N1 N2 2.36795f
C1 N1 VRECT 3.39682f
C2 VMID2 RFN 0.14751f
C3 VRECT RFP 9.60093f
C4 RFN VMID1 0.14751f
C5 VRECT N2 1.26065f
C6 VMID2 RFP 0.1547f
C7 RFP VMID1 0.1547f
C8 VMID2 VRECT 8.5858f
C9 N1 VOUT 0.26461f
C10 RFN RFP 9.69561f
C11 VRECT VMID1 9.27284f
C12 N2 VOUT 2.34819f
C13 VMID2 VMID1 5.96798f
C14 VRECT VOUT 0.63001f
C15 VRECT RFN 7.60045f
C16 VOUT VSS 44.38189f
C17 N2 VSS 30.64052f
C18 N1 VSS 28.28854f
C19 VMID2 VSS 15.97128f
C20 VMID1 VSS 12.38507f
C21 RFP VSS 18.13312f
C22 RFN VSS 20.46017f
C23 VRECT VSS 0.11303p
C24 VRECT.t18 VSS 0.01874f
C25 VRECT.t16 VSS 0.01874f
C26 VRECT.n0 VSS 0.06135f
C27 VRECT.t19 VSS 0.01768f
C28 VRECT.t17 VSS 0.01768f
C29 VRECT.n1 VSS 0.10833f
C30 VRECT.n2 VSS 0.11648f
C31 VRECT.n3 VSS 6.71443f
C32 VRECT.n4 VSS 0.00822f
C33 VRECT.n5 VSS 0.00822f
C34 VRECT.n6 VSS 0.00822f
C35 VRECT.n7 VSS 0.00592f
C36 VRECT.n8 VSS 0.00592f
C37 VRECT.n9 VSS 0.00592f
C38 VRECT.n10 VSS 0.00822f
C39 VRECT.n11 VSS 0.06651f
C40 VRECT.n12 VSS 0.00592f
C41 VRECT.n13 VSS 0.34758f
C42 VRECT.t11 VSS 0.10154f
C43 VRECT.n14 VSS 0.00592f
C44 VRECT.n15 VSS 0.00822f
C45 VRECT.n16 VSS 0.00822f
C46 VRECT.n17 VSS 0.00822f
C47 VRECT.n18 VSS 0.00592f
C48 VRECT.t20 VSS 0.10154f
C49 VRECT.n19 VSS 0.00592f
C50 VRECT.n20 VSS 0.00822f
C51 VRECT.n21 VSS 0.00822f
C52 VRECT.n22 VSS 0.00822f
C53 VRECT.n23 VSS 0.00592f
C54 VRECT.n24 VSS 0.20307f
C55 VRECT.n25 VSS 0.15548f
C56 VRECT.n26 VSS 0.00592f
C57 VRECT.n27 VSS 0.00592f
C58 VRECT.n28 VSS 0.00822f
C59 VRECT.n29 VSS 0.00822f
C60 VRECT.n30 VSS 0.00822f
C61 VRECT.n31 VSS 0.00592f
C62 VRECT.n32 VSS 0.00592f
C63 VRECT.n33 VSS 0.20307f
C64 VRECT.n34 VSS 0.00592f
C65 VRECT.n35 VSS 0.00822f
C66 VRECT.n36 VSS 0.00822f
C67 VRECT.n37 VSS 0.00822f
C68 VRECT.n38 VSS 0.00592f
C69 VRECT.t22 VSS 0.10154f
C70 VRECT.n39 VSS 0.00592f
C71 VRECT.n40 VSS 0.00822f
C72 VRECT.n41 VSS 0.00822f
C73 VRECT.n42 VSS 0.00822f
C74 VRECT.n43 VSS 0.00592f
C75 VRECT.n44 VSS 0.20307f
C76 VRECT.n45 VSS 0.00592f
C77 VRECT.n46 VSS 0.00822f
C78 VRECT.n47 VSS 0.00822f
C79 VRECT.n48 VSS 0.00822f
C80 VRECT.n49 VSS 0.00822f
C81 VRECT.n50 VSS 0.00592f
C82 VRECT.t2 VSS 0.10154f
C83 VRECT.n51 VSS 0.00592f
C84 VRECT.n52 VSS 0.00822f
C85 VRECT.n53 VSS 0.00822f
C86 VRECT.n54 VSS 0.00822f
C87 VRECT.n55 VSS 0.00592f
C88 VRECT.n56 VSS 0.20307f
C89 VRECT.n57 VSS 0.00592f
C90 VRECT.n58 VSS 0.00822f
C91 VRECT.n59 VSS 0.02154f
C92 VRECT.n60 VSS 0.00668f
C93 VRECT.n61 VSS 0.02973f
C94 VRECT.t14 VSS 0.10154f
C95 VRECT.n62 VSS 0.02973f
C96 VRECT.n63 VSS 0.00668f
C97 VRECT.t13 VSS 0.07084f
C98 VRECT.t15 VSS 0.09371f
C99 VRECT.n64 VSS 0.10774f
C100 VRECT.n65 VSS 0.05695f
C101 VRECT.n66 VSS 0.24823f
C102 VRECT.n68 VSS 0.34758f
C103 VRECT.n69 VSS 0.06651f
C104 VRECT.n70 VSS 0.02628f
C105 VRECT.n71 VSS 0.00822f
C106 VRECT.n72 VSS 0.00822f
C107 VRECT.n73 VSS 0.00592f
C108 VRECT.n74 VSS 0.13517f
C109 VRECT.n75 VSS 0.00592f
C110 VRECT.n76 VSS 0.00822f
C111 VRECT.n77 VSS 0.00822f
C112 VRECT.n78 VSS 0.00822f
C113 VRECT.n79 VSS 0.00822f
C114 VRECT.n80 VSS 0.00822f
C115 VRECT.n81 VSS 0.00592f
C116 VRECT.n82 VSS 0.14913f
C117 VRECT.n83 VSS 0.20307f
C118 VRECT.n84 VSS 0.00592f
C119 VRECT.n85 VSS 0.00822f
C120 VRECT.n86 VSS 0.00822f
C121 VRECT.n87 VSS 0.00822f
C122 VRECT.n88 VSS 0.00822f
C123 VRECT.n89 VSS 0.00822f
C124 VRECT.n90 VSS 0.00592f
C125 VRECT.n91 VSS 0.15548f
C126 VRECT.n92 VSS 0.00592f
C127 VRECT.n93 VSS 0.00822f
C128 VRECT.n94 VSS 0.00822f
C129 VRECT.n95 VSS 0.00822f
C130 VRECT.n96 VSS 0.00822f
C131 VRECT.n97 VSS 0.00822f
C132 VRECT.n98 VSS 0.00822f
C133 VRECT.n99 VSS 0.00592f
C134 VRECT.n100 VSS 0.1174f
C135 VRECT.n101 VSS 0.20307f
C136 VRECT.n102 VSS 0.00592f
C137 VRECT.n103 VSS 0.00822f
C138 VRECT.n104 VSS 0.00822f
C139 VRECT.n105 VSS 0.00822f
C140 VRECT.n106 VSS 0.00822f
C141 VRECT.n107 VSS 0.00822f
C142 VRECT.n108 VSS 0.00592f
C143 VRECT.n109 VSS 0.18721f
C144 VRECT.n110 VSS 0.00592f
C145 VRECT.n111 VSS 0.00592f
C146 VRECT.n112 VSS 0.00822f
C147 VRECT.n113 VSS 0.00822f
C148 VRECT.n114 VSS 0.00822f
C149 VRECT.n115 VSS 0.00822f
C150 VRECT.n116 VSS 0.00822f
C151 VRECT.n117 VSS 0.00592f
C152 VRECT.n118 VSS 0.1174f
C153 VRECT.t0 VSS 0.10154f
C154 VRECT.n119 VSS 0.18721f
C155 VRECT.n120 VSS 0.00592f
C156 VRECT.n121 VSS 0.00822f
C157 VRECT.n122 VSS 0.00822f
C158 VRECT.n123 VSS 0.00822f
C159 VRECT.n124 VSS 0.00822f
C160 VRECT.n125 VSS 0.00822f
C161 VRECT.n126 VSS 0.00822f
C162 VRECT.n127 VSS 0.00592f
C163 VRECT.n128 VSS 0.20307f
C164 VRECT.n129 VSS 0.00592f
C165 VRECT.n130 VSS 0.00822f
C166 VRECT.n131 VSS 0.00822f
C167 VRECT.n132 VSS 0.00822f
C168 VRECT.n133 VSS 0.00822f
C169 VRECT.n134 VSS 0.00822f
C170 VRECT.n135 VSS 0.00592f
C171 VRECT.n136 VSS 0.14913f
C172 VRECT.n137 VSS 0.20307f
C173 VRECT.n138 VSS 0.13517f
C174 VRECT.n139 VSS 0.20307f
C175 VRECT.n140 VSS 0.00592f
C176 VRECT.n141 VSS 0.00822f
C177 VRECT.n142 VSS 0.00822f
C178 VRECT.n143 VSS 0.00822f
C179 VRECT.t10 VSS 0.07084f
C180 VRECT.t12 VSS 0.09371f
C181 VRECT.n144 VSS 0.10774f
C182 VRECT.n145 VSS 0.05695f
C183 VRECT.n146 VSS 0.02154f
C184 VRECT.n147 VSS 0.00668f
C185 VRECT.n148 VSS 0.02973f
C186 VRECT.n150 VSS 0.24823f
C187 VRECT.n151 VSS 0.02973f
C188 VRECT.n152 VSS 0.00668f
C189 VRECT.n153 VSS 0.02628f
C190 VRECT.n154 VSS 0.00822f
C191 VRECT.n155 VSS 0.00822f
C192 VRECT.n156 VSS 0.00822f
C193 VRECT.n157 VSS 0.00822f
C194 VRECT.n158 VSS 0.00822f
C195 VRECT.n159 VSS 0.00822f
C196 VRECT.n160 VSS 0.00822f
C197 VRECT.n161 VSS 0.01506f
C198 VRECT.t3 VSS 0.13177f
C199 VRECT.t1 VSS 0.12176f
C200 VRECT.n162 VSS 0.14848f
C201 VRECT.n163 VSS 0.03295f
C202 VRECT.t23 VSS 0.10155f
C203 VRECT.t21 VSS 0.09221f
C204 VRECT.n164 VSS 0.12846f
C205 VRECT.n165 VSS 0.69812f
C206 VRECT.n166 VSS 13.9191f
C207 VRECT.n167 VSS 0.00822f
C208 VRECT.n168 VSS 0.00822f
C209 VRECT.n169 VSS 0.00822f
C210 VRECT.n170 VSS 0.00592f
C211 VRECT.n171 VSS 0.00592f
C212 VRECT.n172 VSS 0.00592f
C213 VRECT.n173 VSS 0.00668f
C214 VRECT.t4 VSS 0.02251f
C215 VRECT.t6 VSS 0.13952f
C216 VRECT.n174 VSS 0.12652f
C217 VRECT.n175 VSS 0.05918f
C218 VRECT.n176 VSS 0.03139f
C219 VRECT.n177 VSS 0.03139f
C220 VRECT.n178 VSS 0.21951f
C221 VRECT.n179 VSS 0.00592f
C222 VRECT.n180 VSS 0.00822f
C223 VRECT.n181 VSS 0.00668f
C224 VRECT.n182 VSS 0.00822f
C225 VRECT.n183 VSS 0.00822f
C226 VRECT.n184 VSS 0.00592f
C227 VRECT.n185 VSS 0.21951f
C228 VRECT.n186 VSS 0.00592f
C229 VRECT.n187 VSS 0.00822f
C230 VRECT.n188 VSS 0.00822f
C231 VRECT.n189 VSS 0.00822f
C232 VRECT.n190 VSS 0.00592f
C233 VRECT.n191 VSS 0.00592f
C234 VRECT.n192 VSS 0.21951f
C235 VRECT.n193 VSS 0.00592f
C236 VRECT.n194 VSS 0.00592f
C237 VRECT.n195 VSS 0.00592f
C238 VRECT.n196 VSS 0.00822f
C239 VRECT.n197 VSS 0.00822f
C240 VRECT.n198 VSS 0.00822f
C241 VRECT.n199 VSS 0.00822f
C242 VRECT.n200 VSS 0.00592f
C243 VRECT.t30 VSS 0.10976f
C244 VRECT.n201 VSS 0.00592f
C245 VRECT.n202 VSS 0.00822f
C246 VRECT.n203 VSS 0.00822f
C247 VRECT.n204 VSS 0.00822f
C248 VRECT.n205 VSS 0.00592f
C249 VRECT.n206 VSS 0.13651f
C250 VRECT.n207 VSS 0.00592f
C251 VRECT.n208 VSS 0.00822f
C252 VRECT.n209 VSS 0.00822f
C253 VRECT.n210 VSS 0.00822f
C254 VRECT.n211 VSS 0.00822f
C255 VRECT.n212 VSS 0.00592f
C256 VRECT.n213 VSS 0.21951f
C257 VRECT.t26 VSS 0.10976f
C258 VRECT.n214 VSS 0.00592f
C259 VRECT.n215 VSS 0.00822f
C260 VRECT.n216 VSS 0.02658f
C261 VRECT.n217 VSS 0.00668f
C262 VRECT.n218 VSS 0.03139f
C263 VRECT.t8 VSS 0.10976f
C264 VRECT.n219 VSS 0.03139f
C265 VRECT.n220 VSS 0.00668f
C266 VRECT.t7 VSS 0.02251f
C267 VRECT.t9 VSS 0.13952f
C268 VRECT.n221 VSS 0.12652f
C269 VRECT.n222 VSS 0.23952f
C270 VRECT.n224 VSS 0.36648f
C271 VRECT.n225 VSS 0.07268f
C272 VRECT.n226 VSS 0.05918f
C273 VRECT.n227 VSS 0.02096f
C274 VRECT.n228 VSS 0.00822f
C275 VRECT.n229 VSS 0.00822f
C276 VRECT.n230 VSS 0.00592f
C277 VRECT.n231 VSS 0.16669f
C278 VRECT.n232 VSS 0.00592f
C279 VRECT.n233 VSS 0.00822f
C280 VRECT.n234 VSS 0.00822f
C281 VRECT.n235 VSS 0.00822f
C282 VRECT.n236 VSS 0.00822f
C283 VRECT.n237 VSS 0.00822f
C284 VRECT.n238 VSS 0.00592f
C285 VRECT.n239 VSS 0.19276f
C286 VRECT.n240 VSS 0.00592f
C287 VRECT.n241 VSS 0.00822f
C288 VRECT.n242 VSS 0.00822f
C289 VRECT.n243 VSS 0.00822f
C290 VRECT.n244 VSS 0.00822f
C291 VRECT.n245 VSS 0.00822f
C292 VRECT.n246 VSS 0.00822f
C293 VRECT.n247 VSS 0.00822f
C294 VRECT.n248 VSS 0.00592f
C295 VRECT.n249 VSS 0.21059f
C296 VRECT.n250 VSS 0.21951f
C297 VRECT.n251 VSS 0.00592f
C298 VRECT.n252 VSS 0.00822f
C299 VRECT.n253 VSS 0.00822f
C300 VRECT.n254 VSS 0.00822f
C301 VRECT.n255 VSS 0.00822f
C302 VRECT.n256 VSS 0.00822f
C303 VRECT.n257 VSS 0.00592f
C304 VRECT.n258 VSS 0.11867f
C305 VRECT.n259 VSS 0.00592f
C306 VRECT.n260 VSS 0.00592f
C307 VRECT.n261 VSS 0.00822f
C308 VRECT.n262 VSS 0.00822f
C309 VRECT.n263 VSS 0.00822f
C310 VRECT.n264 VSS 0.00822f
C311 VRECT.n265 VSS 0.00822f
C312 VRECT.n266 VSS 0.00822f
C313 VRECT.n267 VSS 0.00822f
C314 VRECT.n268 VSS 0.00592f
C315 VRECT.n269 VSS 0.21059f
C316 VRECT.t24 VSS 0.10976f
C317 VRECT.n270 VSS 0.11867f
C318 VRECT.n271 VSS 0.21951f
C319 VRECT.n272 VSS 0.00592f
C320 VRECT.n273 VSS 0.00822f
C321 VRECT.n274 VSS 0.00822f
C322 VRECT.n275 VSS 0.00822f
C323 VRECT.n276 VSS 0.00822f
C324 VRECT.n277 VSS 0.00822f
C325 VRECT.n278 VSS 0.00822f
C326 VRECT.n279 VSS 0.00592f
C327 VRECT.n280 VSS 0.00592f
C328 VRECT.n281 VSS 0.13651f
C329 VRECT.t28 VSS 0.10976f
C330 VRECT.n282 VSS 0.19276f
C331 VRECT.n283 VSS 0.00592f
C332 VRECT.n284 VSS 0.00822f
C333 VRECT.n285 VSS 0.00822f
C334 VRECT.n286 VSS 0.00822f
C335 VRECT.n287 VSS 0.02096f
C336 VRECT.n288 VSS 0.00822f
C337 VRECT.n289 VSS 0.00822f
C338 VRECT.n290 VSS 0.00592f
C339 VRECT.n291 VSS 0.16669f
C340 VRECT.t5 VSS 0.10976f
C341 VRECT.n292 VSS 0.23952f
C342 VRECT.n294 VSS 0.36648f
C343 VRECT.n295 VSS 0.07268f
C344 VRECT.n296 VSS 0.02658f
C345 VRECT.n297 VSS 0.00822f
C346 VRECT.n298 VSS 0.00822f
C347 VRECT.n299 VSS 0.00822f
C348 VRECT.n300 VSS 0.00822f
C349 VRECT.n301 VSS 0.00822f
C350 VRECT.n302 VSS 0.00822f
C351 VRECT.n303 VSS 0.01023f
C352 VRECT.t27 VSS 0.17901f
C353 VRECT.t25 VSS 0.1718f
C354 VRECT.n304 VSS 0.15092f
C355 VRECT.n305 VSS 0.02745f
C356 VRECT.t31 VSS 0.15332f
C357 VRECT.t29 VSS 0.14375f
C358 VRECT.n306 VSS 0.13058f
C359 VRECT.n307 VSS 0.71536f
C360 VRECT.n308 VSS 1.73288f
C361 RFN.t4 VSS 0.06459f
C362 RFN.t5 VSS 0.06621f
C363 RFN.n0 VSS 0.43785f
C364 RFN.n1 VSS 5.90166f
C365 RFN.t3 VSS 0.42457f
C366 RFN.t2 VSS 0.42972f
C367 RFN.n2 VSS 0.62497f
C368 RFN.n3 VSS 0.68588f
C369 RFN.t6 VSS 0.1017f
C370 RFN.t7 VSS 0.10297f
C371 RFN.n4 VSS 0.46273f
C372 RFN.n5 VSS 0.75678f
C373 RFN.t1 VSS 0.71585f
C374 RFN.t0 VSS 0.72159f
C375 RFN.n6 VSS 0.62668f
C376 RFN.n7 VSS 0.31157f
C377 RFP.t4 VSS 0.10099f
C378 RFP.t5 VSS 0.09929f
C379 RFP.n0 VSS 0.61681f
C380 RFP.n1 VSS 6.49746f
C381 RFP.t2 VSS 0.37451f
C382 RFP.t1 VSS 0.37795f
C383 RFP.n2 VSS 0.63352f
C384 RFP.n3 VSS 0.84179f
C385 RFP.t6 VSS 0.14583f
C386 RFP.t7 VSS 0.14439f
C387 RFP.n4 VSS 0.64936f
C388 RFP.n5 VSS 0.92928f
C389 RFP.t0 VSS 0.7139f
C390 RFP.t3 VSS 0.71879f
C391 RFP.n6 VSS 0.67145f
C392 RFP.n7 VSS 0.33733f
C393 VMID1.t6 VSS 0.74181f
C394 VMID1.t2 VSS 0.74032f
C395 VMID1.n0 VSS 1.46324f
C396 VMID1.t7 VSS 0.63645f
C397 VMID1.t3 VSS 0.6138f
C398 VMID1.n1 VSS 1.77357f
C399 VMID1.n2 VSS -2.61882f
C400 VMID1.t0 VSS 1.13818f
C401 VMID1.t4 VSS 1.13781f
C402 VMID1.n3 VSS 2.26558f
C403 VMID1.n4 VSS 2.20772f
C404 VMID1.t1 VSS 1.43267f
C405 VMID1.t5 VSS 1.40459f
C406 VMID1.n5 VSS 1.81387f
C407 VMID1.n6 VSS 0.69866f
C408 VMID2.t6 VSS 0.57304f
C409 VMID2.t0 VSS 0.57379f
C410 VMID2.n0 VSS 1.1266f
C411 VMID2.t7 VSS 0.6788f
C412 VMID2.t1 VSS 0.66465f
C413 VMID2.n1 VSS 1.58333f
C414 VMID2.n2 VSS -0.27751f
C415 VMID2.t2 VSS 0.87582f
C416 VMID2.t4 VSS 0.87605f
C417 VMID2.n3 VSS 1.64121f
C418 VMID2.n4 VSS 1.60161f
C419 VMID2.t3 VSS 1.3024f
C420 VMID2.t5 VSS 1.28727f
C421 VMID2.n5 VSS 1.51765f
C422 VMID2.n6 VSS 0.76342f
C423 N1.t4 VSS 0.06442f
C424 N1.t5 VSS 0.06522f
C425 N1.t2 VSS 0.0103f
C426 N1.t0 VSS 0.0103f
C427 N1.n0 VSS 0.03371f
C428 N1.t3 VSS 0.00971f
C429 N1.t1 VSS 0.00971f
C430 N1.n1 VSS 0.05952f
C431 N1.n2 VSS 2.88578f
C432 N1.n3 VSS 2.86166f
C433 N2.t0 VSS 0.05794f
C434 N2.t1 VSS 0.05865f
C435 N2.t4 VSS 0.00926f
C436 N2.t2 VSS 0.00926f
C437 N2.n0 VSS 0.03032f
C438 N2.t5 VSS 0.00873f
C439 N2.t3 VSS 0.00873f
C440 N2.n1 VSS 0.05353f
C441 N2.n2 VSS 2.87146f
C442 N2.n3 VSS 2.85178f
C443 VOUT.t2 VSS 0.10541f
C444 VOUT.t0 VSS 0.02725f
C445 VOUT.t1 VSS 0.02769f
C446 VOUT.n0 VSS 1.43633f
C447 VOUT.t3 VSS 0.0036f
.ends
