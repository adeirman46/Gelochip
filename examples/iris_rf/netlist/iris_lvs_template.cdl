* IRIS LVS reference netlist
.SUBCKT iris rfp rfn vout vss
XBIAS rfp rfn gatep gaten vrect vss iris_startup_bias
XRECT rfp rfn gatep gaten vrect vss iris_rectifier
XPUMP rfp rfn vrect vout vss iris_charge_pump
.ENDS iris

.SUBCKT iris_startup_bias rfp rfn gatep gaten vrect vss
CIJP rfn gatep $[mim_single_2p0fF] M=1 l={CINJ_SIDE}u w={CINJ_SIDE}u
CIJN rfp gaten $[mim_single_2p0fF] M=1 l={CINJ_SIDE}u w={CINJ_SIDE}u
MPBIASP gatep vrect vrect vrect pmos_3p3 m=1 w={BIAS_PMOS_W}u l={BIAS_PMOS_L}u nf=1
MPBIASN gaten vrect vrect vrect pmos_3p3 m=1 w={BIAS_PMOS_W}u l={BIAS_PMOS_L}u nf=1
MNBIASP gatep vss vss vss nmos_3p3 m=1 w={BIAS_NMOS_W}u l={BIAS_NMOS_L}u nf=1
MNBIASN gaten vss vss vss nmos_3p3 m=1 w={BIAS_NMOS_W}u l={BIAS_NMOS_L}u nf=1
.ENDS iris_startup_bias

.SUBCKT iris_rectifier rfp rfn gatep gaten vrect vss
MPP1 vrect gaten rfp vrect pmos_3p3 m=1 w={RECT_PMOS_W}u l={RECT_PMOS_L}u nf={RECT_PMOS_NF}
MPP2 vrect gatep rfn vrect pmos_3p3 m=1 w={RECT_PMOS_W}u l={RECT_PMOS_L}u nf={RECT_PMOS_NF}
MNN1 rfp gaten vss vss nmos_3p3 m=1 w={RECT_NMOS_W}u l={RECT_NMOS_L}u nf={RECT_NMOS_NF}
MNN2 rfn gatep vss vss nmos_3p3 m=1 w={RECT_NMOS_W}u l={RECT_NMOS_L}u nf={RECT_NMOS_NF}
.ENDS iris_rectifier

.SUBCKT iris_charge_pump rfp rfn vrect vout vss
MCP1 vrect vrect n1 n1 nmos_3p3 m=1 w={CP_DIODE_W}u l={CP_DIODE_L}u nf={CP_DIODE_NF}
MCP2 n1 n1 n2 n2 nmos_3p3 m=1 w={CP_DIODE_W}u l={CP_DIODE_L}u nf={CP_DIODE_NF}
MCP3 n2 n2 vout vout nmos_3p3 m=1 w={CP_DIODE_W}u l={CP_DIODE_L}u nf={CP_DIODE_NF}
CCP1 rfp n1 $[mim_single_2p0fF] M=1 l={CSTAGE_SIDE}u w={CSTAGE_SIDE}u
CCP2 rfn n2 $[mim_single_2p0fF] M=1 l={CSTAGE_SIDE}u w={CSTAGE_SIDE}u
CCP3 rfp vout $[mim_single_2p0fF] M=1 l={CSTAGE_SIDE}u w={CSTAGE_SIDE}u
CSTORE vout vss $[mim_single_2p0fF] M=1 l={CSTORE_SIDE}u w={CSTORE_SIDE}u
.ENDS iris_charge_pump
